* Suarez DAC extracted-layout qualification
.include /foss/designs/outputs/suarez_dac/sim/models/sky130_tt.spice
.include /foss/designs/outputs/suarez_dac/verification/signoff/powerup_dut.spice
.temp 27
VDD vdd 0 PWL(0 0 10u 1.8)
VHI refh 0 PWL(0 0 10u 0 15u .9)
VLO refl 0 PWL(0 0 10u 0 15u .2)
RHI refh hi 500
RLO refl lo 500
CHI hi 0 5p
CLO lo 0 5p
ROUT out pad 500
COUT pad 0 5p
RLOAD pad 0 10Meg
Rfixture_clk unused_clk 0 1T
Rfixture_ena unused_ena 0 1T
Rfixture_rst_n unused_rst_n 0 1T
Rfixture_ua_3_ unused_ua_3_ 0 1T
Rfixture_ua_4_ unused_ua_4_ 0 1T
Rfixture_ua_5_ unused_ua_5_ 0 1T
Rfixture_ua_6_ unused_ua_6_ 0 1T
Rfixture_ua_7_ unused_ua_7_ 0 1T
Rfixture_ui_in_3_ unused_ui_in_3_ 0 1T
Rfixture_ui_in_4_ unused_ui_in_4_ 0 1T
Rfixture_ui_in_5_ unused_ui_in_5_ 0 1T
Rfixture_ui_in_6_ unused_ui_in_6_ 0 1T
Rfixture_ui_in_7_ unused_ui_in_7_ 0 1T
Rfixture_uio_in_0_ unused_uio_in_0_ 0 1T
Rfixture_uio_in_1_ unused_uio_in_1_ 0 1T
Rfixture_uio_in_2_ unused_uio_in_2_ 0 1T
Rfixture_uio_in_3_ unused_uio_in_3_ 0 1T
Rfixture_uio_in_4_ unused_uio_in_4_ 0 1T
Rfixture_uio_in_5_ unused_uio_in_5_ 0 1T
Rfixture_uio_in_6_ unused_uio_in_6_ 0 1T
Rfixture_uio_in_7_ unused_uio_in_7_ 0 1T
Rfixture_uio_oe_0_ unused_uio_oe_0_ 0 1T
Rfixture_uio_oe_1_ unused_uio_oe_1_ 0 1T
Rfixture_uio_oe_2_ unused_uio_oe_2_ 0 1T
Rfixture_uio_oe_3_ unused_uio_oe_3_ 0 1T
Rfixture_uio_oe_4_ unused_uio_oe_4_ 0 1T
Rfixture_uio_oe_5_ unused_uio_oe_5_ 0 1T
Rfixture_uio_oe_6_ unused_uio_oe_6_ 0 1T
Rfixture_uio_oe_7_ unused_uio_oe_7_ 0 1T
Rfixture_uio_out_0_ unused_uio_out_0_ 0 1T
Rfixture_uio_out_1_ unused_uio_out_1_ 0 1T
Rfixture_uio_out_2_ unused_uio_out_2_ 0 1T
Rfixture_uio_out_3_ unused_uio_out_3_ 0 1T
Rfixture_uio_out_4_ unused_uio_out_4_ 0 1T
Rfixture_uio_out_5_ unused_uio_out_5_ 0 1T
Rfixture_uio_out_6_ unused_uio_out_6_ 0 1T
Rfixture_uio_out_7_ unused_uio_out_7_ 0 1T
Rfixture_uo_out_0_ unused_uo_out_0_ 0 1T
Rfixture_uo_out_1_ unused_uo_out_1_ 0 1T
Rfixture_uo_out_2_ unused_uo_out_2_ 0 1T
Rfixture_uo_out_3_ unused_uo_out_3_ 0 1T
Rfixture_uo_out_4_ unused_uo_out_4_ 0 1T
Rfixture_uo_out_5_ unused_uo_out_5_ 0 1T
Rfixture_uo_out_6_ unused_uo_out_6_ 0 1T
Rfixture_uo_out_7_ unused_uo_out_7_ 0 1T
XDUT unused_clk unused_ena unused_rst_n hi out lo unused_ua_3_ unused_ua_4_ unused_ua_5_ unused_ua_6_ unused_ua_7_ h l s unused_ui_in_3_ unused_ui_in_4_ unused_ui_in_5_ unused_ui_in_6_ unused_ui_in_7_ unused_uio_in_0_ unused_uio_in_1_ unused_uio_in_2_ unused_uio_in_3_ unused_uio_in_4_ unused_uio_in_5_ unused_uio_in_6_ unused_uio_in_7_ unused_uio_oe_0_ unused_uio_oe_1_ unused_uio_oe_2_ unused_uio_oe_3_ unused_uio_oe_4_ unused_uio_oe_5_ unused_uio_oe_6_ unused_uio_oe_7_ unused_uio_out_0_ unused_uio_out_1_ unused_uio_out_2_ unused_uio_out_3_ unused_uio_out_4_ unused_uio_out_5_ unused_uio_out_6_ unused_uio_out_7_ unused_uo_out_0_ unused_uo_out_1_ unused_uo_out_2_ unused_uo_out_3_ unused_uo_out_4_ unused_uo_out_5_ unused_uo_out_6_ unused_uo_out_7_ 0 vdd tt_um_jonah_suarez_dac_pex
.options method=trap reltol=1e-5 abstol=1e-13 vntol=1e-7
Vh h 0 PWL(0 0 20.000000u 0 28.200000u 0 28.205000u 1.8 30.200000u 1.8 30.205000u 0 32.600000u 0 32.605000u 1.8 34.600000u 1.8 34.605000u 0 37.000000u 0 37.005000u 1.8 39.000000u 1.8 39.005000u 0 41.400000u 0 41.405000u 1.8 43.400000u 1.8 43.405000u 0 45.800000u 0 45.805000u 1.8 47.800000u 1.8 47.805000u 0 50.200000u 0 50.205000u 1.8 52.200000u 1.8 52.205000u 0 54.600000u 0 54.605000u 1.8 56.600000u 1.8 56.605000u 0 59.000000u 0 59.005000u 1.8 61.000000u 1.8 61.005000u 0 66.900000u 0)
Vl l 0 PWL(0 0 20.000000u 0 20.100000u 0 20.105000u 1.8 28.000000u 1.8 28.005000u 0 66.900000u 0)
Vs s 0 PWL(0 0 20.000000u 0 20.100000u 0 20.105000u 1.8 28.000000u 1.8 28.005000u 0 30.400000u 0 30.405000u 1.8 32.400000u 1.8 32.405000u 0 34.800000u 0 34.805000u 1.8 36.800000u 1.8 36.805000u 0 39.200000u 0 39.205000u 1.8 41.200000u 1.8 41.205000u 0 43.600000u 0 43.605000u 1.8 45.600000u 1.8 45.605000u 0 48.000000u 0 48.005000u 1.8 50.000000u 1.8 50.005000u 0 52.400000u 0 52.405000u 1.8 54.400000u 1.8 54.405000u 0 56.800000u 0 56.805000u 1.8 58.800000u 1.8 58.805000u 0 61.200000u 0 61.205000u 1.8 63.200000u 1.8 63.205000u 0 66.900000u 0)
.control
set num_threads=1
set wr_vecnames
set wr_singlescale
tran 25n 66.900000u 0 25n uic
wrdata /foss/designs/outputs/suarez_dac/verification/signoff/powerup.txt v(XDUT.HOLD) v(out) v(pad) i(VDD) i(VHI) i(VLO)
quit
.endc
.end
