* NGSPICE file created from tt_um_jonah_suarez_dac_flat.ext - technology: sky130A

.subckt tt_um_jonah_suarez_dac_flat clk ena rst_n ua[0] ua[1] ua[2] ua[3] ua[4] ua[5]
+ ua[6] ua[7] ui_in[0] ui_in[1] ui_in[2] ui_in[3] ui_in[4] ui_in[5] ui_in[6] ui_in[7]
+ uio_in[0] uio_in[1] uio_in[2] uio_in[3] uio_in[4] uio_in[5] uio_in[6] uio_in[7]
+ uio_oe[0] uio_oe[1] uio_oe[2] uio_oe[3] uio_oe[4] uio_oe[5] uio_oe[6] uio_oe[7]
+ uio_out[0] uio_out[1] uio_out[2] uio_out[3] uio_out[4] uio_out[5] uio_out[6] uio_out[7]
+ uo_out[0] uo_out[1] uo_out[2] uo_out[3] uo_out[4] uo_out[5] uo_out[6] uo_out[7]
+ VGND VDPWR
X0 RBMID VGND VGND sky130_fd_pr__res_xhigh_po_0p35 l=30
R0 VGND uio_out[0] 0.000000
R1 VGND uo_out[3] 0.000000
X1 TAIL ua[1] MIRROR VDPWR sky130_fd_pr__pfet_01v8_lvt ad=1.16 pd=8.58 as=1.16 ps=8.58 w=4 l=1
X2 HOLD VGND sky130_fd_pr__cap_mim_m3_1 l=14 w=14
X3 HOLD VGND sky130_fd_pr__cap_mim_m3_1 l=14 w=14
X4 SAMPLE VGND sky130_fd_pr__cap_mim_m3_1 l=14 w=14
R2 VGND uio_oe[7] 0.000000
R3 VGND uo_out[2] 0.000000
X5 HOLD VGND sky130_fd_pr__cap_mim_m3_1 l=14 w=14
R4 VGND uio_oe[6] 0.000000
R5 VGND uo_out[1] 0.000000
R6 VGND uio_oe[5] 0.000000
R7 VGND uo_out[0] 0.000000
X6 SAMPLE VGND sky130_fd_pr__cap_mim_m3_1 l=14 w=14
R8 VGND uio_oe[4] 0.000000
R9 VGND uio_out[7] 0.000000
X7 HOLD S_BAR SAMPLE VDPWR sky130_fd_pr__pfet_01v8_lvt ad=0.58 pd=4.58 as=0.58 ps=4.58 w=2 l=0.35
X8 SAMPLE VGND sky130_fd_pr__cap_mim_m3_1 l=14 w=14
R10 VGND uio_oe[2] 0.000000
R11 VGND uio_oe[3] 0.000000
R12 VGND uio_out[5] 0.000000
R13 VGND uio_out[6] 0.000000
X9 VDPWR BIAS TAIL VDPWR sky130_fd_pr__pfet_01v8 ad=1.16 pd=8.58 as=1.16 ps=8.58 w=4 l=2
R14 VGND uio_out[4] 0.000000
R15 VGND uo_out[7] 0.000000
X10 SAMPLE L_BAR ua[2] VDPWR sky130_fd_pr__pfet_01v8_lvt ad=0.58 pd=4.58 as=0.58 ps=4.58 w=2 l=0.35
X11 VDPWR BIAS BIAS VDPWR sky130_fd_pr__pfet_01v8 ad=1.16 pd=8.58 as=1.16 ps=8.58 w=4 l=2
R16 VGND uo_out[6] 0.000000
X12 SAMPLE VGND sky130_fd_pr__cap_mim_m3_1 l=14 w=14
X13 HOLD VGND sky130_fd_pr__cap_mim_m3_1 l=14 w=14
X14 SAMPLE H_BAR ua[0] VDPWR sky130_fd_pr__pfet_01v8_lvt ad=0.58 pd=4.58 as=0.58 ps=4.58 w=2 l=0.35
X15 SAMPLE VGND sky130_fd_pr__cap_mim_m3_1 l=14 w=14
X16 HOLD VGND sky130_fd_pr__cap_mim_m3_1 l=14 w=14
X17 SAMPLE VGND sky130_fd_pr__cap_mim_m3_1 l=14 w=14
X18 SAMPLE VGND sky130_fd_pr__cap_mim_m3_1 l=14 w=14
X19 COMP ua[1] sky130_fd_pr__cap_mim_m3_1 l=26 w=26
X20 VGND MIRROR MIRROR VGND sky130_fd_pr__nfet_01v8 ad=1.16 pd=8.58 as=1.16 ps=8.58 w=4 l=2
X21 HOLD VGND sky130_fd_pr__cap_mim_m3_1 l=14 w=14
X22 SAMPLE VGND sky130_fd_pr__cap_mim_m3_1 l=14 w=14
X23 HOLD VGND sky130_fd_pr__cap_mim_m3_1 l=14 w=14
X24 BIAS RBMID VGND sky130_fd_pr__res_xhigh_po_0p35 l=30
X25 TAIL HOLD AMP VDPWR sky130_fd_pr__pfet_01v8_lvt ad=1.16 pd=8.58 as=1.16 ps=8.58 w=4 l=1
X26 HOLD VGND sky130_fd_pr__cap_mim_m3_1 l=14 w=14
X27 VDPWR BIAS ua[1] VDPWR sky130_fd_pr__pfet_01v8 ad=6.96 pd=48.58 as=6.96 ps=48.58 w=24 l=2
X28 SAMPLE VGND sky130_fd_pr__cap_mim_m3_1 l=14 w=14
X29 HOLD VGND sky130_fd_pr__cap_mim_m3_1 l=14 w=14
X30 SAMPLE VGND sky130_fd_pr__cap_mim_m3_1 l=14 w=14
X31 VGND AMP ua[1] VGND sky130_fd_pr__nfet_01v8 ad=5.8 pd=40.58 as=5.8 ps=40.58 w=20 l=1
X32 SAMPLE VGND sky130_fd_pr__cap_mim_m3_1 l=14 w=14
X33 VDPWR ui_in[2] S_BAR VDPWR sky130_fd_pr__pfet_01v8 ad=0.58 pd=4.58 as=0.58 ps=4.58 w=2 l=0.15
X34 SAMPLE VGND sky130_fd_pr__cap_mim_m3_1 l=14 w=14
X35 SAMPLE VGND sky130_fd_pr__cap_mim_m3_1 l=14 w=14
X36 AMP COMP VGND sky130_fd_pr__res_xhigh_po_0p35 l=14
X37 HOLD VGND sky130_fd_pr__cap_mim_m3_1 l=14 w=14
X38 VDPWR ui_in[1] L_BAR VDPWR sky130_fd_pr__pfet_01v8 ad=0.58 pd=4.58 as=0.58 ps=4.58 w=2 l=0.15
X39 VGND ui_in[2] S_BAR VGND sky130_fd_pr__nfet_01v8 ad=0.29 pd=2.58 as=0.29 ps=2.58 w=1 l=0.15
X40 HOLD ui_in[2] SAMPLE VGND sky130_fd_pr__nfet_01v8 ad=0.29 pd=2.58 as=0.29 ps=2.58 w=1 l=0.15
X41 HOLD VGND sky130_fd_pr__cap_mim_m3_1 l=14 w=14
X42 SAMPLE VGND sky130_fd_pr__cap_mim_m3_1 l=14 w=14
X43 VDPWR ui_in[0] H_BAR VDPWR sky130_fd_pr__pfet_01v8 ad=0.58 pd=4.58 as=0.58 ps=4.58 w=2 l=0.15
X44 VGND ui_in[1] L_BAR VGND sky130_fd_pr__nfet_01v8 ad=0.29 pd=2.58 as=0.29 ps=2.58 w=1 l=0.15
X45 SAMPLE ui_in[1] ua[2] VGND sky130_fd_pr__nfet_01v8 ad=0.29 pd=2.58 as=0.29 ps=2.58 w=1 l=0.15
X46 HOLD VGND sky130_fd_pr__cap_mim_m3_1 l=14 w=14
X47 SAMPLE VGND sky130_fd_pr__cap_mim_m3_1 l=14 w=14
X48 VGND ui_in[0] H_BAR VGND sky130_fd_pr__nfet_01v8 ad=0.29 pd=2.58 as=0.29 ps=2.58 w=1 l=0.15
X49 SAMPLE ui_in[0] ua[0] VGND sky130_fd_pr__nfet_01v8 ad=0.29 pd=2.58 as=0.29 ps=2.58 w=1 l=0.15
R17 VGND uio_oe[0] 0.000000
R18 VGND uio_oe[1] 0.000000
R19 VGND uio_out[3] 0.000000
X50 VGND MIRROR AMP VGND sky130_fd_pr__nfet_01v8 ad=1.16 pd=8.58 as=1.16 ps=8.58 w=4 l=2
X51 HOLD VGND sky130_fd_pr__cap_mim_m3_1 l=14 w=14
X52 HOLD VGND sky130_fd_pr__cap_mim_m3_1 l=14 w=14
R20 VGND uio_out[2] 0.000000
R21 VGND uo_out[5] 0.000000
X53 SAMPLE VGND sky130_fd_pr__cap_mim_m3_1 l=14 w=14
X54 HOLD VGND sky130_fd_pr__cap_mim_m3_1 l=14 w=14
X55 HOLD VGND sky130_fd_pr__cap_mim_m3_1 l=14 w=14
R22 VGND uio_out[1] 0.000000
R23 VGND uo_out[4] 0.000000
.ends
