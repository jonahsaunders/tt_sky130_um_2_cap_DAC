* PEX produced on Fri Oct  2 07:27:08 PM CEST 2026 using /foss/tools/sak/sak-pex.sh with m=3 and s=1 (extresist threshold=1000 mOhm, minres=1000 mOhm, mindelay=0 ps)
* NGSPICE file created from tt_um_jonah_suarez_dac_pex.ext - technology: sky130A

.subckt tt_um_jonah_suarez_dac_pex clk ena rst_n ua[0] ua[1] ua[2] ua[3] ua[4] ua[5]  ua[6] ua[7] ui_in[0] ui_in[1] ui_in[2] ui_in[3] ui_in[4] ui_in[5] ui_in[6] ui_in[7]  uio_in[0] uio_in[1] uio_in[2] uio_in[3] uio_in[4] uio_in[5] uio_in[6] uio_in[7]  uio_oe[0] uio_oe[1] uio_oe[2] uio_oe[3] uio_oe[4] uio_oe[5] uio_oe[6] uio_oe[7]  uio_out[0] uio_out[1] uio_out[2] uio_out[3] uio_out[4] uio_out[5] uio_out[6] uio_out[7]  uo_out[0] uo_out[1] uo_out[2] uo_out[3] uo_out[4] uo_out[5] uo_out[6] uo_out[7]  VGND VDPWR
X0 RBMID VGND.t17 VGND.t16 sky130_fd_pr__res_xhigh_po_0p35 l=30
X1 TAIL.t2 ua[1].t4 MIRROR.t2 VDPWR.t16 sky130_fd_pr__pfet_01v8_lvt ad=1.16 pd=8.58 as=1.16 ps=8.58 w=4 l=1
X2 HOLD VGND.t4 sky130_fd_pr__cap_mim_m3_1 l=14 w=14
X3 HOLD VGND.t14 sky130_fd_pr__cap_mim_m3_1 l=14 w=14
X4 SAMPLE VGND.t8 sky130_fd_pr__cap_mim_m3_1 l=14 w=14
X5 HOLD VGND.t2 sky130_fd_pr__cap_mim_m3_1 l=14 w=14
X6 SAMPLE VGND.t18 sky130_fd_pr__cap_mim_m3_1 l=14 w=14
X7 HOLD.t0 S_BAR.t2 SAMPLE.t1 VDPWR.t1 sky130_fd_pr__pfet_01v8_lvt ad=0.58 pd=4.58 as=0.58 ps=4.58 w=2 l=0.35
X8 SAMPLE VGND.t4 sky130_fd_pr__cap_mim_m3_1 l=14 w=14
X9 VDPWR.t3 BIAS.t4 TAIL.t0 VDPWR.t2 sky130_fd_pr__pfet_01v8 ad=1.16 pd=8.58 as=1.16 ps=8.58 w=4 l=2
X10 SAMPLE.t2 L_BAR.t2 ua[2].t1 VDPWR.t4 sky130_fd_pr__pfet_01v8_lvt ad=0.58 pd=4.58 as=0.58 ps=4.58 w=2 l=0.35
X11 VDPWR.t15 BIAS.t0 BIAS.t1 VDPWR.t14 sky130_fd_pr__pfet_01v8 ad=1.16 pd=8.58 as=1.16 ps=8.58 w=4 l=2
X12 SAMPLE VGND.t22 sky130_fd_pr__cap_mim_m3_1 l=14 w=14
X13 HOLD VGND.t24 sky130_fd_pr__cap_mim_m3_1 l=14 w=14
X14 SAMPLE.t0 H_BAR.t2 ua[0].t0 VDPWR.t0 sky130_fd_pr__pfet_01v8_lvt ad=0.58 pd=4.58 as=0.58 ps=4.58 w=2 l=0.35
X15 SAMPLE VGND.t24 sky130_fd_pr__cap_mim_m3_1 l=14 w=14
X16 HOLD VGND.t14 sky130_fd_pr__cap_mim_m3_1 l=14 w=14
X17 SAMPLE VGND.t8 sky130_fd_pr__cap_mim_m3_1 l=14 w=14
X18 SAMPLE VGND.t22 sky130_fd_pr__cap_mim_m3_1 l=14 w=14
X19 COMP ua[1].t2 sky130_fd_pr__cap_mim_m3_1 l=26 w=26
X20 VGND.t7 MIRROR.t0 MIRROR.t1 VGND.t6 sky130_fd_pr__nfet_01v8 ad=1.16 pd=8.58 as=1.16 ps=8.58 w=4 l=2
X21 HOLD VGND.t34 sky130_fd_pr__cap_mim_m3_1 l=14 w=14
X22 SAMPLE VGND.t2 sky130_fd_pr__cap_mim_m3_1 l=14 w=14
X23 HOLD VGND.t24 sky130_fd_pr__cap_mim_m3_1 l=14 w=14
X24 BIAS.t2 RBMID VGND.t40 sky130_fd_pr__res_xhigh_po_0p35 l=30
X25 TAIL.t1 HOLD.t2 AMP.t0 VDPWR.t13 sky130_fd_pr__pfet_01v8_lvt ad=1.16 pd=8.58 as=1.16 ps=8.58 w=4 l=1
X26 HOLD VGND.t4 sky130_fd_pr__cap_mim_m3_1 l=14 w=14
X27 VDPWR.t10 BIAS.t3 ua[1].t1 VDPWR.t9 sky130_fd_pr__pfet_01v8 ad=6.96 pd=48.58 as=6.96 ps=48.58 w=24 l=2
X28 SAMPLE VGND.t14 sky130_fd_pr__cap_mim_m3_1 l=14 w=14
X29 HOLD VGND.t18 sky130_fd_pr__cap_mim_m3_1 l=14 w=14
X30 SAMPLE VGND.t8 sky130_fd_pr__cap_mim_m3_1 l=14 w=14
X31 VGND.t1 AMP.t3 ua[1].t0 VGND.t0 sky130_fd_pr__nfet_01v8 ad=5.8 pd=40.58 as=5.8 ps=40.58 w=20 l=1
X32 SAMPLE VGND.t18 sky130_fd_pr__cap_mim_m3_1 l=14 w=14
X33 VDPWR.t8 ui_in[2].t1 S_BAR.t0 VDPWR.t7 sky130_fd_pr__pfet_01v8 ad=0.58 pd=4.58 as=0.58 ps=4.58 w=2 l=0.15
X34 SAMPLE VGND.t2 sky130_fd_pr__cap_mim_m3_1 l=14 w=14
X35 SAMPLE VGND.t14 sky130_fd_pr__cap_mim_m3_1 l=14 w=14
X36 AMP.t1 COMP VGND.t39 sky130_fd_pr__res_xhigh_po_0p35 l=14
X37 HOLD VGND.t22 sky130_fd_pr__cap_mim_m3_1 l=14 w=14
X38 VDPWR.t6 ui_in[1].t1 L_BAR.t0 VDPWR.t5 sky130_fd_pr__pfet_01v8 ad=0.58 pd=4.58 as=0.58 ps=4.58 w=2 l=0.15
X39 VGND.t29 ui_in[2].t2 S_BAR.t1 VGND.t28 sky130_fd_pr__nfet_01v8 ad=0.29 pd=2.58 as=0.29 ps=2.58 w=1 l=0.15
X40 HOLD.t1 ui_in[2].t0 SAMPLE.t4 VGND.t30 sky130_fd_pr__nfet_01v8 ad=0.29 pd=2.58 as=0.29 ps=2.58 w=1 l=0.15
X41 HOLD VGND.t14 sky130_fd_pr__cap_mim_m3_1 l=14 w=14
X42 SAMPLE VGND.t24 sky130_fd_pr__cap_mim_m3_1 l=14 w=14
X43 VDPWR.t12 ui_in[0].t1 H_BAR.t0 VDPWR.t11 sky130_fd_pr__pfet_01v8 ad=0.58 pd=4.58 as=0.58 ps=4.58 w=2 l=0.15
X44 VGND.t11 ui_in[1].t2 L_BAR.t1 VGND.t10 sky130_fd_pr__nfet_01v8 ad=0.29 pd=2.58 as=0.29 ps=2.58 w=1 l=0.15
X45 SAMPLE.t3 ui_in[1].t0 ua[2].t0 VGND.t12 sky130_fd_pr__nfet_01v8 ad=0.29 pd=2.58 as=0.29 ps=2.58 w=1 l=0.15
X46 HOLD VGND.t8 sky130_fd_pr__cap_mim_m3_1 l=14 w=14
X47 SAMPLE VGND.t34 sky130_fd_pr__cap_mim_m3_1 l=14 w=14
X48 VGND.t32 ui_in[0].t2 H_BAR.t1 VGND.t31 sky130_fd_pr__nfet_01v8 ad=0.29 pd=2.58 as=0.29 ps=2.58 w=1 l=0.15
X49 SAMPLE.t5 ui_in[0].t0 ua[0].t1 VGND.t33 sky130_fd_pr__nfet_01v8 ad=0.29 pd=2.58 as=0.29 ps=2.58 w=1 l=0.15
X50 VGND.t47 MIRROR.t3 AMP.t2 VGND.t46 sky130_fd_pr__nfet_01v8 ad=1.16 pd=8.58 as=1.16 ps=8.58 w=4 l=2
X51 HOLD VGND.t2 sky130_fd_pr__cap_mim_m3_1 l=14 w=14
X52 HOLD VGND.t8 sky130_fd_pr__cap_mim_m3_1 l=14 w=14
X53 SAMPLE VGND.t4 sky130_fd_pr__cap_mim_m3_1 l=14 w=14
X54 HOLD VGND.t22 sky130_fd_pr__cap_mim_m3_1 l=14 w=14
X55 HOLD VGND.t8 sky130_fd_pr__cap_mim_m3_1 l=14 w=14
C0 ui_in[0] ui_in[1] 10.0952f
C1 ua[1] L_BAR 0.25864f
C2 ui_in[2] AMP 0.98483f
C3 MIRROR L_BAR 0.29233f
C4 ua[2] L_BAR 0.83209f
C5 ua[1] VDPWR 4.91321f
C6 ua[0] HOLD 1.92283f
C7 ui_in[2] H_BAR 8.31028f
C8 RBMID L_BAR 0.0358f
C9 BIAS L_BAR 0.34113f
C10 VDPWR MIRROR 1.68631f
C11 ua[2] VDPWR 1.01747f
C12 VDPWR RBMID 0.28684f
C13 ua[1] S_BAR 0.38115f
C14 VDPWR BIAS 7.53415f
C15 ui_in[2] COMP 0.14016f
C16 S_BAR MIRROR 0.29265f
C17 ua[2] S_BAR 0.20212f
C18 AMP L_BAR 0.28845f
C19 S_BAR RBMID 0.0359f
C20 S_BAR BIAS 0.34783f
C21 ua[1] TAIL 1.33161f
C22 ui_in[0] rst_n 0.0338f
C23 VDPWR AMP 1.34866f
C24 ua[1] SAMPLE 2.09161f
C25 H_BAR L_BAR 12.5777f
C26 TAIL MIRROR 13.3001f
C27 ua[2] TAIL 0.22855f
C28 ui_in[2] ua[0] 0.2728f
C29 ui_in[1] ua[1] 0.2536f
C30 SAMPLE MIRROR 0.2942f
C31 ui_in[2] HOLD 1.46301f
C32 ua[2] SAMPLE 14.2278f
C33 TAIL RBMID 0.23821f
C34 VDPWR H_BAR 1.72793f
C35 TAIL BIAS 1.40751f
C36 SAMPLE RBMID 0.59915f
C37 COMP L_BAR 0.05106f
C38 S_BAR AMP 0.26045f
C39 ui_in[1] MIRROR 0.94885f
C40 ui_in[1] ua[2] 1.37928f
C41 SAMPLE BIAS 0.83061f
C42 ui_in[0] ua[1] 0.8664f
C43 ui_in[1] RBMID 0.13299f
C44 VDPWR COMP 0.28701f
C45 ui_in[1] BIAS 0.33645f
C46 ui_in[0] MIRROR 0.39081f
C47 S_BAR H_BAR 0.24004f
C48 ui_in[0] ua[2] 0.28268f
C49 ui_in[2] ui_in[3] 0.0337f
C50 ui_in[0] RBMID 0.10825f
C51 TAIL AMP 12.9239f
C52 ui_in[0] BIAS 0.35307f
C53 ui_in[3] ui_in[4] 0.03102f
C54 SAMPLE AMP 0.79332f
C55 S_BAR COMP 0.03565f
C56 ua[0] L_BAR 0.20298f
C57 TAIL H_BAR 0.22804f
C58 HOLD L_BAR 0.38171f
C59 ui_in[1] AMP 0.27846f
C60 SAMPLE H_BAR 1.12355f
C61 ua[0] VDPWR 1.04175f
C62 HOLD VDPWR 2.25981f
C63 ui_in[0] AMP 0.26137f
C64 ui_in[1] H_BAR 0.7214f
C65 TAIL COMP 0.04324f
C66 uio_in[7] uio_in[6] 0.03102f
C67 rst_n clk 0.03102f
C68 SAMPLE COMP 0.7053f
C69 ui_in[0] H_BAR 2.81182f
C70 ua[0] S_BAR 12.6255f
C71 HOLD S_BAR 0.93102f
C72 ui_in[1] COMP 0.11071f
C73 uio_in[6] uio_in[5] 0.03102f
C74 ui_in[0] COMP 0.10877f
C75 ua[0] TAIL 0.22843f
C76 ui_in[2] L_BAR 0.14181f
C77 ua[1] MIRROR 1.32139f
C78 ua[2] ua[1] 4.43061f
C79 HOLD TAIL 1.17688f
C80 uio_in[1] uio_in[0] 0.03102f
C81 ua[0] SAMPLE 1.71138f
C82 HOLD SAMPLE 8.30022f
C83 ua[1] RBMID 0.48319f
C84 ua[2] MIRROR 0.29307f
C85 ua[1] BIAS 2.97628f
C86 ui_in[2] VDPWR 1.43854f
C87 ua[0] ui_in[1] 0.28312f
C88 ui_in[1] HOLD 0.37571f
C89 RBMID MIRROR 12.5866f
C90 ua[2] RBMID 0.24289f
C91 BIAS MIRROR 0.3024f
C92 ua[2] BIAS 1.68269f
C93 ua[0] ui_in[0] 1.32612f
C94 BIAS RBMID 23.9308f
C95 uio_in[0] ui_in[7] 0.03102f
C96 ui_in[2] S_BAR 2.63849f
C97 ui_in[0] HOLD 0.32935f
C98 ua[1] AMP 2.29462f
C99 AMP MIRROR 1.22162f
C100 ua[2] AMP 0.80826f
C101 ua[1] H_BAR 0.2702f
C102 ui_in[2] TAIL 0.2973f
C103 AMP RBMID 11.574f
C104 VDPWR L_BAR 1.55482f
C105 AMP BIAS 0.52533f
C106 uio_in[5] uio_in[4] 0.03102f
C107 ui_in[2] SAMPLE 1.69574f
C108 MIRROR H_BAR 0.29233f
C109 ua[2] H_BAR 0.19024f
C110 ua[1] COMP 82.3275f
C111 ui_in[2] ui_in[1] 8.74581f
C112 RBMID H_BAR 0.05065f
C113 ui_in[6] ui_in[7] 0.03102f
C114 BIAS H_BAR 0.37998f
C115 S_BAR L_BAR 12.5615f
C116 uio_in[2] uio_in[1] 0.03102f
C117 COMP MIRROR 0.0405f
C118 ua[2] COMP 0.13664f
C119 ui_in[2] ui_in[0] 0.28413f
C120 COMP RBMID 0.36287f
C121 S_BAR VDPWR 1.55542f
C122 BIAS COMP 0.3221f
C123 clk ena 0.03102f
C124 TAIL L_BAR 0.22804f
C125 AMP H_BAR 0.27157f
C126 ua[0] ua[1] 6.81716f
C127 SAMPLE L_BAR 1.23778f
C128 HOLD ua[1] 2.47254f
C129 VDPWR TAIL 4.56924f
C130 ua[0] MIRROR 0.29287f
C131 ui_in[6] ui_in[5] 0.03102f
C132 ua[0] ua[2] 12.7773f
C133 ui_in[1] L_BAR 2.54425f
C134 HOLD MIRROR 0.29634f
C135 AMP COMP 23.7447f
C136 SAMPLE VDPWR 4.09568f
C137 HOLD ua[2] 0.80336f
C138 ua[0] RBMID 0.12586f
C139 ua[0] BIAS 0.87598f
C140 HOLD RBMID 0.53879f
C141 ui_in[1] VDPWR 1.45182f
C142 HOLD BIAS 13.3112f
C143 uio_in[4] uio_in[3] 0.03102f
C144 ui_in[0] L_BAR 0.29941f
C145 COMP H_BAR 0.03544f
C146 S_BAR TAIL 0.22804f
C147 S_BAR SAMPLE 1.17049f
C148 ui_in[5] ui_in[4] 0.03102f
C149 ui_in[0] VDPWR 12.0698f
C150 ui_in[1] S_BAR 0.30523f
C151 ua[0] AMP 0.34733f
C152 uio_in[3] uio_in[2] 0.03102f
C153 HOLD AMP 1.70679f
C154 ui_in[2] ua[1] 0.29879f
C155 ui_in[0] S_BAR 0.29095f
C156 SAMPLE TAIL 0.22928f
C157 ua[0] H_BAR 0.81317f
C158 ui_in[2] MIRROR 1.04052f
C159 HOLD H_BAR 0.26882f
C160 ui_in[2] ua[2] 0.2684f
C161 ui_in[1] TAIL 0.3036f
C162 ui_in[1] SAMPLE 1.67437f
C163 ui_in[2] RBMID 0.09816f
C164 ui_in[2] BIAS 0.32783f
C165 ua[0] COMP 0.18969f
C166 ui_in[0] TAIL 0.30167f
C167 HOLD COMP 0.5665f
C168 ui_in[0] SAMPLE 1.64428f
C169 ua[3] VGND 0.16449f
C170 ua[4] VGND 0.16449f
C171 ua[5] VGND 0.16449f
C172 ua[6] VGND 0.16608f
C173 ua[7] VGND 0.16735f
C174 ena VGND 0.07268f
C175 clk VGND 0.04517f
C176 rst_n VGND 0.04463f
C177 ui_in[3] VGND 0.04463f
C178 ui_in[4] VGND 0.04517f
C179 ui_in[5] VGND 0.04517f
C180 ui_in[6] VGND 0.04516f
C181 ui_in[7] VGND 0.04514f
C182 uio_in[0] VGND 0.04517f
C183 uio_in[1] VGND 0.04516f
C184 uio_in[2] VGND 0.04517f
C185 uio_in[3] VGND 0.04517f
C186 uio_in[4] VGND 0.04517f
C187 uio_in[5] VGND 0.04517f
C188 uio_in[6] VGND 0.04529f
C189 uio_in[7] VGND 0.07796f
C190 ua[1] VGND 76.24689f
C191 ua[2] VGND 41.8017f
C192 ua[0] VGND 47.7877f
C193 ui_in[2] VGND 8.78736f
C194 ui_in[1] VGND 9.49176f
C195 ui_in[0] VGND 10.67025f
C196 VDPWR VGND 91.4733f
C197 RBMID VGND 31.8777f
C198 MIRROR VGND 17.74122f
C199 AMP VGND 37.79737f
C200 TAIL VGND 13.69949f
C201 S_BAR VGND 11.93955f
C202 L_BAR VGND 11.046f
C203 H_BAR VGND 33.37724f
C204 BIAS VGND 39.41548f
C205 BIAS.n0 VGND 9.04349f
C206 BIAS.n1 VGND 0.0186f
C207 BIAS.t1 VGND 0.54817f
C208 BIAS.n2 VGND 0.14139f
C209 BIAS.n3 VGND 0.01068f
C210 BIAS.n4 VGND 2.03377f
C211 BIAS.n5 VGND 0.03309f
C212 BIAS.n6 VGND 1.42105f
C213 BIAS.n7 VGND 0.01068f
C214 BIAS.n8 VGND 0.43094f
C215 BIAS.n9 VGND 0.03309f
C216 BIAS.n10 VGND 0.99575f
C217 BIAS.n11 VGND 0.01068f
C218 BIAS.n12 VGND 0.43094f
C219 BIAS.n13 VGND 0.03309f
C220 BIAS.n14 VGND 0.99575f
C221 BIAS.t2 VGND 0.12514f
C222 BIAS.n15 VGND 16.6449f
C223 BIAS.n16 VGND 12.1852f
C224 BIAS.n17 VGND 1.19349f
C225 H_BAR.n0 VGND 0.03742f
C226 H_BAR.t0 VGND 0.15655f
C227 H_BAR.n1 VGND 0.01213f
C228 H_BAR.t1 VGND 0.08203f
C229 H_BAR.n2 VGND 0.06604f
C230 H_BAR.n3 VGND 0.02091f
C231 H_BAR.n4 VGND 1.42252f
C232 H_BAR.n5 VGND 1.577f
C233 H_BAR.n6 VGND 0.03684f
C234 L_BAR.n0 VGND 24.2872f
C235 L_BAR.n1 VGND 0.04127f
C236 L_BAR.t0 VGND 0.16692f
C237 L_BAR.n2 VGND 0.01338f
C238 L_BAR.t1 VGND 0.08607f
C239 L_BAR.n3 VGND 0.07284f
C240 L_BAR.n4 VGND 0.02306f
C241 L_BAR.n5 VGND 1.63126f
C242 L_BAR.n6 VGND 1.80166f
C243 L_BAR.n7 VGND 0.04063f
C244 S_BAR.n0 VGND 23.7042f
C245 S_BAR.n1 VGND 0.04113f
C246 S_BAR.t0 VGND 0.16874f
C247 S_BAR.n2 VGND 0.01333f
C248 S_BAR.t1 VGND 0.0887f
C249 S_BAR.n3 VGND 0.07259f
C250 S_BAR.n4 VGND 0.02298f
C251 S_BAR.n5 VGND 1.68761f
C252 S_BAR.n6 VGND 1.85743f
C253 S_BAR.n7 VGND 0.04049f
C254 SAMPLE.n0 VGND 0.36459f
C255 SAMPLE.n1 VGND 0.10171f
C256 SAMPLE.n2 VGND 0.12455f
C257 SAMPLE.t3 VGND 0.05943f
C258 SAMPLE.t1 VGND 0.12535f
C259 SAMPLE.n7 VGND 0.05089f
C260 SAMPLE.t4 VGND 0.06197f
C261 SAMPLE.n11 VGND 0.0371f
C262 SAMPLE.t2 VGND 0.12578f
C263 SAMPLE.n14 VGND 0.04122f
C264 SAMPLE.n15 VGND 0.12146f
C265 SAMPLE.n16 VGND 0.0904f
C266 SAMPLE.n17 VGND 0.23101f
C267 SAMPLE.n18 VGND 0.14134f
C268 SAMPLE.n19 VGND 0.09947f
C269 SAMPLE.n20 VGND 0.06164f
C270 SAMPLE.n21 VGND 0.1742f
C271 SAMPLE.n22 VGND 0.14134f
C272 SAMPLE.n23 VGND 0.09947f
C273 SAMPLE.n24 VGND 0.06164f
C274 SAMPLE.n25 VGND 0.0667f
C275 SAMPLE.n26 VGND 0.12146f
C276 SAMPLE.n27 VGND 0.0904f
C277 SAMPLE.n28 VGND 0.08246f
C278 SAMPLE.n29 VGND 0.1256f
C279 SAMPLE.n30 VGND 0.12763f
C280 SAMPLE.t5 VGND 0.05773f
C281 SAMPLE.n34 VGND 0.0371f
C282 SAMPLE.t0 VGND 0.11421f
C283 SAMPLE.n37 VGND 0.04122f
C284 SAMPLE.n38 VGND 0.0371f
C285 HOLD.n0 VGND 0.35462f
C286 HOLD.t1 VGND 0.06192f
C287 HOLD.n6 VGND 0.05196f
C288 HOLD.t0 VGND 0.12511f
C289 HOLD.n9 VGND 0.03829f
C290 HOLD.n10 VGND 0.1245f
C291 HOLD.n11 VGND 0.08743f
C292 HOLD.n12 VGND 0.18261f
C293 HOLD.n13 VGND 0.10698f
C294 HOLD.n14 VGND 0.07101f
C295 HOLD.n15 VGND 0.07574f
C296 HOLD.n16 VGND 0.15802f
C297 HOLD.n17 VGND 0.10698f
C298 HOLD.n18 VGND 0.07101f
C299 HOLD.n19 VGND 0.07574f
C300 HOLD.n20 VGND 0.04549f
C301 HOLD.n21 VGND 0.1245f
C302 HOLD.n22 VGND 0.08743f
C303 HOLD.n23 VGND 0.05936f
C304 HOLD.n24 VGND 0.11863f
C305 HOLD.n25 VGND 0.15056f
C306 HOLD.n26 VGND 0.03469f
C307 TAIL.n0 VGND 2.45182f
C308 TAIL.n1 VGND 2.75858f
C309 TAIL.n2 VGND 2.43317f
C310 TAIL.t2 VGND 0.55414f
C311 TAIL.t0 VGND 0.82885f
C312 TAIL.n3 VGND 9.95729f
C313 TAIL.n4 VGND 11.5242f
C314 TAIL.t1 VGND 0.33601f
C315 AMP.n0 VGND 1.65346f
C316 AMP.n2 VGND 0.01746f
C317 AMP.n3 VGND 1.0896f
C318 AMP.n4 VGND 0.01746f
C319 AMP.n5 VGND 1.28009f
C320 AMP.t2 VGND 0.93894f
C321 AMP.n6 VGND 5.86835f
C322 AMP.t1 VGND 0.15754f
C323 AMP.n7 VGND 21.7464f
C324 AMP.n8 VGND 14.9369f
C325 AMP.n9 VGND 4.3368f
C326 AMP.n10 VGND 1.66999f
C327 AMP.t0 VGND 0.06736f
C328 AMP.n11 VGND 0.17799f
C329 AMP.n12 VGND 0.02341f
C330 MIRROR.n0 VGND 16.807f
C331 MIRROR.n1 VGND 1.83112f
C332 MIRROR.n3 VGND 0.01511f
C333 MIRROR.n4 VGND 0.61136f
C334 MIRROR.n5 VGND 0.04722f
C335 MIRROR.n6 VGND 1.74068f
C336 MIRROR.n7 VGND 0.01511f
C337 MIRROR.n8 VGND 0.61136f
C338 MIRROR.n9 VGND 0.04722f
C339 MIRROR.n10 VGND 1.54639f
C340 MIRROR.t1 VGND 0.97211f
C341 MIRROR.n11 VGND 1.84963f
C342 MIRROR.t2 VGND 0.29493f
C343 MIRROR.n12 VGND 0.20673f
C344 MIRROR.n13 VGND 0.02719f
C345 VGND.t4 VGND 0.4586p
C346 VGND.t8 VGND 0.46963p
C347 VGND.t11 VGND 0.06237f
C348 VGND.t29 VGND 0.06509f
C349 VGND.t7 VGND 0.73356f
C350 VGND.t47 VGND 0.73356f
C351 VGND.t1 VGND 1.52641f
C352 VGND.t32 VGND 0.06055f
C353 VDPWR.n0 VGND 1.81508f
C354 VDPWR.n1 VGND 1.75738f
C355 VDPWR.n2 VGND 1.34868f
C356 VDPWR.n3 VGND 1.32203f
C357 VDPWR.n4 VGND 8.11562f
C358 VDPWR.t12 VGND 0.10484f
C359 VDPWR.t11 VGND 0.03867f
C360 VDPWR.n9 VGND 0.13078f
C361 VDPWR.n16 VGND 0.08984f
C362 VDPWR.n27 VGND 0.13078f
C363 VDPWR.n48 VGND 0.08984f
C364 VDPWR.n51 VGND 0.17184f
C365 VDPWR.n52 VGND 1.51379f
C366 VDPWR.t6 VGND 0.10525f
C367 VDPWR.t5 VGND 0.03867f
C368 VDPWR.n57 VGND 0.13078f
C369 VDPWR.n64 VGND 0.08984f
C370 VDPWR.n75 VGND 0.13078f
C371 VDPWR.n96 VGND 0.08984f
C372 VDPWR.n99 VGND 0.17184f
C373 VDPWR.t8 VGND 0.10742f
C374 VDPWR.t7 VGND 0.03867f
C375 VDPWR.n104 VGND 0.13078f
C376 VDPWR.n111 VGND 0.08984f
C377 VDPWR.n122 VGND 0.13078f
C378 VDPWR.n143 VGND 0.08984f
C379 VDPWR.n146 VGND 0.17184f
C380 VDPWR.n152 VGND 0.04652f
C381 VDPWR.n153 VGND 0.0797f
C382 VDPWR.t0 VGND 0.02326f
C383 VDPWR.n161 VGND 0.04652f
C384 VDPWR.n162 VGND 0.03557f
C385 VDPWR.n166 VGND 0.0797f
C386 VDPWR.n174 VGND 0.0667f
C387 VDPWR.n180 VGND 0.04652f
C388 VDPWR.n187 VGND 0.03421f
C389 VDPWR.n193 VGND 0.0667f
C390 VDPWR.n197 VGND 0.17356f
C391 VDPWR.n198 VGND 0.79486f
C392 VDPWR.n204 VGND 0.04652f
C393 VDPWR.n205 VGND 0.0797f
C394 VDPWR.t4 VGND 0.02326f
C395 VDPWR.n213 VGND 0.04652f
C396 VDPWR.n214 VGND 0.03557f
C397 VDPWR.n218 VGND 0.0797f
C398 VDPWR.n226 VGND 0.0667f
C399 VDPWR.n232 VGND 0.04652f
C400 VDPWR.n239 VGND 0.03421f
C401 VDPWR.n245 VGND 0.0667f
C402 VDPWR.n249 VGND 0.17356f
C403 VDPWR.n250 VGND 0.79486f
C404 VDPWR.n256 VGND 0.04652f
C405 VDPWR.n257 VGND 0.0797f
C406 VDPWR.t1 VGND 0.02326f
C407 VDPWR.n265 VGND 0.04652f
C408 VDPWR.n266 VGND 0.03557f
C409 VDPWR.n270 VGND 0.0797f
C410 VDPWR.n278 VGND 0.0667f
C411 VDPWR.n284 VGND 0.04652f
C412 VDPWR.n291 VGND 0.03421f
C413 VDPWR.n297 VGND 0.0667f
C414 VDPWR.n301 VGND 0.17356f
C415 VDPWR.t15 VGND 0.62513f
C416 VDPWR.t14 VGND 0.0588f
C417 VDPWR.n306 VGND 0.11761f
C418 VDPWR.n311 VGND 0.11761f
C419 VDPWR.n315 VGND 0.18247f
C420 VDPWR.n348 VGND 0.1496f
C421 VDPWR.n354 VGND 0.08821f
C422 VDPWR.n355 VGND 0.11761f
C423 VDPWR.n396 VGND 0.18247f
C424 VDPWR.n397 VGND 0.1496f
C425 VDPWR.n398 VGND 0.11761f
C426 VDPWR.n404 VGND 0.08821f
C427 VDPWR.n407 VGND 0.17993f
C428 VDPWR.t3 VGND 0.62513f
C429 VDPWR.t2 VGND 0.0588f
C430 VDPWR.n412 VGND 0.11761f
C431 VDPWR.n417 VGND 0.11761f
C432 VDPWR.n421 VGND 0.18247f
C433 VDPWR.n454 VGND 0.1496f
C434 VDPWR.n460 VGND 0.08821f
C435 VDPWR.n461 VGND 0.11761f
C436 VDPWR.n503 VGND 0.18247f
C437 VDPWR.n504 VGND 0.1496f
C438 VDPWR.n505 VGND 0.11761f
C439 VDPWR.n511 VGND 0.08821f
C440 VDPWR.n514 VGND 0.17993f
C441 VDPWR.n518 VGND 0.10037f
C442 VDPWR.n521 VGND 0.05961f
C443 VDPWR.n528 VGND 0.05961f
C444 VDPWR.n532 VGND 0.04383f
C445 VDPWR.n536 VGND 0.05961f
C446 VDPWR.n540 VGND 0.05961f
C447 VDPWR.n544 VGND 0.05961f
C448 VDPWR.n548 VGND 0.10037f
C449 VDPWR.n561 VGND 0.08372f
C450 VDPWR.n567 VGND 0.05961f
C451 VDPWR.n573 VGND 0.05961f
C452 VDPWR.t13 VGND 0.02981f
C453 VDPWR.n579 VGND 0.04558f
C454 VDPWR.n585 VGND 0.05961f
C455 VDPWR.n592 VGND 0.05961f
C456 VDPWR.n599 VGND 0.08372f
C457 VDPWR.n605 VGND 0.18164f
C458 VDPWR.n609 VGND 0.10037f
C459 VDPWR.n612 VGND 0.05961f
C460 VDPWR.n619 VGND 0.05961f
C461 VDPWR.n623 VGND 0.04383f
C462 VDPWR.n627 VGND 0.05961f
C463 VDPWR.n631 VGND 0.05961f
C464 VDPWR.n635 VGND 0.05961f
C465 VDPWR.n639 VGND 0.10037f
C466 VDPWR.n652 VGND 0.08372f
C467 VDPWR.n658 VGND 0.05961f
C468 VDPWR.n664 VGND 0.05961f
C469 VDPWR.t16 VGND 0.02981f
C470 VDPWR.n670 VGND 0.04558f
C471 VDPWR.n676 VGND 0.05961f
C472 VDPWR.n683 VGND 0.05961f
C473 VDPWR.n690 VGND 0.08372f
C474 VDPWR.n696 VGND 0.18164f
C475 VDPWR.n697 VGND 0.79713f
C476 VDPWR.t10 VGND 3.0047f
C477 VDPWR.t9 VGND 0.26019f
C478 VDPWR.n702 VGND 0.52038f
C479 VDPWR.n707 VGND 0.52038f
C480 VDPWR.n711 VGND 0.80735f
C481 VDPWR.n887 VGND 0.66195f
C482 VDPWR.n893 VGND 0.39028f
C483 VDPWR.n894 VGND 0.52038f
C484 VDPWR.n1079 VGND 0.80735f
C485 VDPWR.n1080 VGND 0.66195f
C486 VDPWR.n1081 VGND 0.52038f
C487 VDPWR.n1087 VGND 0.39028f
C488 VDPWR.n1090 VGND 0.26544f
C489 ui_in[0].n0 VGND 9.33619f
C490 ui_in[0].n1 VGND 17.5209f
C491 ui_in[1].n0 VGND 9.61269f
C492 ui_in[1].n1 VGND 16.0641f
C493 ui_in[2].n0 VGND 10.0181f
C494 ui_in[2].n1 VGND 14.7781f
C495 ua[0].t0 VGND 0.28072f
C496 ua[0].t1 VGND 0.25673f
C497 ua[0].n0 VGND 27.0004f
C498 ua[2].t1 VGND 0.30058f
C499 ua[2].t0 VGND 0.27576f
C500 ua[2].n0 VGND 27.2913f
C501 ua[1].t0 VGND 1.94604f
C502 ua[1].t1 VGND 3.15339f
C503 ua[1].n0 VGND 6.78146f
C504 ua[1].n1 VGND 8.98482f
C505 ua[1].t2 VGND 0.11262p
C506 ua[1].n2 VGND 14.0576f
* Exact static resistor-node elimination; every capacitive/device/port node preserved.
RRED0 ua[1].n0 ua[1].t1 213.772
RRED1 ua[1].n0 ua[1].t0 111.499
RRED2 ua[1].n0 ua[1].n1 2.12594
RRED3 ua[1].n1 ua[1].t4 204.377
RRED4 ua[1].n1 ua[1].n2 62.0103
RRED5 ua[1].n2 ua[1] 50.1363
RRED6 ua[1].n2 ua[1].t2 35.2999
RRED7 ua[2].n0 ua[2].t1 222.99
RRED8 ua[2].n0 ua[2].t0 103.486
RRED9 ua[2].n0 ua[2] 99.88
RRED10 ua[0].n0 ua[0].t0 222.678
RRED11 ua[0].n0 ua[0] 105.169
RRED12 ua[0].n0 ua[0].t1 103.172
RRED13 ui_in[2].n0 ui_in[2].t1 570.654
RRED14 ui_in[2].n0 ui_in[2].t2 396.457
RRED15 ui_in[2].n0 ui_in[2].n1 3.9015
RRED16 ui_in[2].n1 ui_in[2].t0 395.69
RRED17 ui_in[2].n1 ui_in[2] 21.8246
RRED18 ui_in[1].n0 ui_in[1].t1 570.341
RRED19 ui_in[1].n0 ui_in[1].t2 396.144
RRED20 ui_in[1].n0 ui_in[1].n1 3.9015
RRED21 ui_in[1].n1 ui_in[1].t0 395.377
RRED22 ui_in[1].n1 ui_in[1] 23.8902
RRED23 ui_in[0].n0 ui_in[0].t1 570.029
RRED24 ui_in[0].n0 ui_in[0].t2 395.832
RRED25 ui_in[0].n0 ui_in[0].n1 3.9015
RRED26 ui_in[0].n1 ui_in[0].t0 395.065
RRED27 ui_in[0].n1 ui_in[0] 26.0576
RRED28 VDPWR.n155 VDPWR.n153 143.09541854548
RRED29 VDPWR.n155 VDPWR.n197 177.00637391425
RRED30 VDPWR.n155 VDPWR.n193 1685.4540472442
RRED31 VDPWR.n155 VDPWR.n184 12289.063387642
RRED32 VDPWR.n155 VDPWR.n189 966.53618553119
RRED33 VDPWR.n155 VDPWR.n152 5677.4329808242
RRED34 VDPWR.n155 VDPWR.n157 35216.685773301
RRED35 VDPWR.n155 VDPWR.n187 27146.195283586
RRED36 VDPWR.n155 VDPWR.n186 188499.86435873
RRED37 VDPWR.n207 VDPWR.n205 143.09541854548
RRED38 VDPWR.n207 VDPWR.n249 177.00637391425
RRED39 VDPWR.n207 VDPWR.n245 1685.4540472442
RRED40 VDPWR.n207 VDPWR.n236 12289.063387642
RRED41 VDPWR.n207 VDPWR.n241 966.53618553119
RRED42 VDPWR.n207 VDPWR.n204 5677.4329808242
RRED43 VDPWR.n207 VDPWR.n209 35216.685773301
RRED44 VDPWR.n207 VDPWR.n239 27146.195283586
RRED45 VDPWR.n207 VDPWR.n238 188499.86435873
RRED46 VDPWR.n259 VDPWR.n257 143.09541854548
RRED47 VDPWR.n259 VDPWR.n301 177.00637391425
RRED48 VDPWR.n259 VDPWR.n297 1685.4540472442
RRED49 VDPWR.n259 VDPWR.n288 12289.063387642
RRED50 VDPWR.n259 VDPWR.n293 966.53618553119
RRED51 VDPWR.n259 VDPWR.n256 5677.4329808242
RRED52 VDPWR.n259 VDPWR.n261 35216.685773301
RRED53 VDPWR.n259 VDPWR.n291 27146.195283586
RRED54 VDPWR.n259 VDPWR.n290 188499.86435873
RRED55 VDPWR.n598 VDPWR.n599 184.99505113864
RRED56 VDPWR.n598 VDPWR.n518 1635.5445400952
RRED57 VDPWR.n598 VDPWR.n596 404.66684324833
RRED58 VDPWR.n598 VDPWR.n594 262.97347622758
RRED59 VDPWR.n598 VDPWR.n605 12286.892779842
RRED60 VDPWR.n598 VDPWR.n521 725.35686498668
RRED61 VDPWR.n598 VDPWR.n527 4323.5295969988
RRED62 VDPWR.n598 VDPWR.n592 3332.7207310199
RRED63 VDPWR.n598 VDPWR.n520 613604.12549934
RRED64 VDPWR.n598 VDPWR.n519 8971520.7345306
RRED65 VDPWR.n560 VDPWR.n561 184.91740985585
RRED66 VDPWR.n560 VDPWR.n558 292.11555553858
RRED67 VDPWR.n560 VDPWR.n548 1583.4036618332
RRED68 VDPWR.n560 VDPWR.n544 618.36919502227
RRED69 VDPWR.n560 VDPWR.n567 1538.4302593846
RRED70 VDPWR.n560 VDPWR.n539 627730.66339158
RRED71 VDPWR.n560 VDPWR.n575 153036.03681806
RRED72 VDPWR.n560 VDPWR.n535 3402.5480838273
RRED73 VDPWR.n560 VDPWR.n581 853.36150668696
RRED74 VDPWR.n560 VDPWR.n573 5851.2863542868
RRED75 VDPWR.n560 VDPWR.n540 2981.7142833104
RRED76 VDPWR.n689 VDPWR.n690 184.99505113864
RRED77 VDPWR.n689 VDPWR.n609 1635.5445400952
RRED78 VDPWR.n689 VDPWR.n687 404.66684324833
RRED79 VDPWR.n689 VDPWR.n685 262.97347622758
RRED80 VDPWR.n689 VDPWR.n696 12286.892779842
RRED81 VDPWR.n689 VDPWR.n612 725.35686498668
RRED82 VDPWR.n689 VDPWR.n618 4323.5295969988
RRED83 VDPWR.n689 VDPWR.n683 3332.7207310199
RRED84 VDPWR.n689 VDPWR.n611 613604.12549934
RRED85 VDPWR.n689 VDPWR.n610 8971520.7345306
RRED86 VDPWR.n651 VDPWR.n652 184.91740985585
RRED87 VDPWR.n651 VDPWR.n649 292.11555553858
RRED88 VDPWR.n651 VDPWR.n639 1583.4036618332
RRED89 VDPWR.n651 VDPWR.n635 618.36919502227
RRED90 VDPWR.n651 VDPWR.n658 1538.4302593846
RRED91 VDPWR.n651 VDPWR.n630 627730.66339158
RRED92 VDPWR.n651 VDPWR.n666 153036.03681806
RRED93 VDPWR.n651 VDPWR.n626 3402.5480838273
RRED94 VDPWR.n651 VDPWR.n672 853.36150668696
RRED95 VDPWR.n651 VDPWR.n664 5851.2863542868
RRED96 VDPWR.n651 VDPWR.n631 2981.7142833104
RRED97 VDPWR.n362 VDPWR.n397 184.99528387495
RRED98 VDPWR.n362 VDPWR.n373 320.83309089414
RRED99 VDPWR.n362 VDPWR.n398 654.97644886288
RRED100 VDPWR.n362 VDPWR.n396 1539.5132699674
RRED101 VDPWR.n362 VDPWR.n306 1959.4876151836
RRED102 VDPWR.n362 VDPWR.n304 8170.8273952397
RRED103 VDPWR.n362 VDPWR.n404 6298.3461171639
RRED104 VDPWR.n362 VDPWR.n407 409.58481465085
RRED105 VDPWR.n362 VDPWR.n400 536683.96563953
RRED106 VDPWR.n362 VDPWR.n308 43254747.807935
RRED107 VDPWR.n347 VDPWR.n348 184.99022563681
RRED108 VDPWR.n347 VDPWR.n345 290.5367875172
RRED109 VDPWR.n347 VDPWR.n315 1538.746119708
RRED110 VDPWR.n347 VDPWR.n311 619.41945186479
RRED111 VDPWR.n347 VDPWR.n355 1543.2946321083
RRED112 VDPWR.n347 VDPWR.n304 6872412.140132
RRED113 VDPWR.n347 VDPWR.n407 1023624.5841834
RRED114 VDPWR.n347 VDPWR.n308 3413.6092150138
RRED115 VDPWR.n347 VDPWR.n400 856.23831984653
RRED116 VDPWR.n347 VDPWR.n404 5869.4415825658
RRED117 VDPWR.n347 VDPWR.n354 2989.8931786535
RRED118 VDPWR.n468 VDPWR.n504 184.99111960599
RRED119 VDPWR.n468 VDPWR.n479 320.83032103925
RRED120 VDPWR.n468 VDPWR.n505 654.92635009267
RRED121 VDPWR.n468 VDPWR.n503 1538.8583488694
RRED122 VDPWR.n468 VDPWR.n412 1959.4876151836
RRED123 VDPWR.n468 VDPWR.n410 8170.8273952397
RRED124 VDPWR.n468 VDPWR.n511 6298.3461171639
RRED125 VDPWR.n468 VDPWR.n514 409.58481465085
RRED126 VDPWR.n468 VDPWR.n414 3806404.2804099
RRED127 VDPWR.n468 VDPWR.n509 925192.8749955
RRED128 VDPWR.n453 VDPWR.n454 184.94181948592
RRED129 VDPWR.n453 VDPWR.n452 149.70391822127
RRED130 VDPWR.n453 VDPWR.n421 1099.8741443002
RRED131 VDPWR.n453 VDPWR.n417 776.23687771775
RRED132 VDPWR.n453 VDPWR.n461 3004.8230992672
RRED133 VDPWR.n453 VDPWR.n509 2252.4201164942
RRED134 VDPWR.n453 VDPWR.n460 10721.147850589
RRED135 VDPWR.n453 VDPWR.n414 63903.993031999
RRED136 VDPWR.n453 VDPWR.n511 49259.327962166
RRED137 VDPWR.n453 VDPWR.n410 1154266.1661035
RRED138 VDPWR.n453 VDPWR.n514 171924.36837124
RRED139 VDPWR.n193 VDPWR.n153 246.38075589636
RRED140 VDPWR.n193 VDPWR.n152 123.29691371344
RRED141 VDPWR.n193 VDPWR.n197 979.74449246634
RRED142 VDPWR.n193 VDPWR.n189 652.18065068966
RRED143 VDPWR.n193 VDPWR.n157 11337.578664155
RRED144 VDPWR.n193 VDPWR.n187 8739.3835536196
RRED145 VDPWR.n193 VDPWR.n184 525.60868656433
RRED146 VDPWR.n193 VDPWR.n186 2995.5550561079
RRED147 VDPWR.n153 VDPWR.n197 260.22450244106
RRED148 VDPWR.n153 VDPWR.n184 1693.2310888325
RRED149 VDPWR.n153 VDPWR.n186 25972.185227221
RRED150 VDPWR.n153 VDPWR.n152 20020.22611265
RRED151 VDPWR.n174 VDPWR.n166 202.20287778615
RRED152 VDPWR.n174 VDPWR.n161 127.6404483052
RRED153 VDPWR.n174 VDPWR.n160 584.20267284268
RRED154 VDPWR.n174 VDPWR.n182 705.46176839388
RRED155 VDPWR.n174 VDPWR.n157 2950.2530076068
RRED156 VDPWR.n174 VDPWR.n189 903.68287547011
RRED157 VDPWR.n174 VDPWR.n180 4148.1938634048
RRED158 VDPWR.n166 VDPWR.n160 1526.0827722068
RRED159 VDPWR.n166 VDPWR.n182 473.41749234025
RRED160 VDPWR.n166 VDPWR.n157 3139.3180929504
RRED161 VDPWR.n166 VDPWR.n189 781.42628371416
RRED162 VDPWR.n166 VDPWR.n180 5449.4074141582
RRED163 VDPWR.n166 VDPWR.n161 2841.9232494736
RRED164 VDPWR.n245 VDPWR.n205 246.38075589636
RRED165 VDPWR.n245 VDPWR.n204 123.29691371344
RRED166 VDPWR.n245 VDPWR.n249 979.74449246634
RRED167 VDPWR.n245 VDPWR.n241 652.18065068966
RRED168 VDPWR.n245 VDPWR.n209 11337.578664155
RRED169 VDPWR.n245 VDPWR.n239 8739.3835536196
RRED170 VDPWR.n245 VDPWR.n236 525.60868656433
RRED171 VDPWR.n245 VDPWR.n238 2995.5550561079
RRED172 VDPWR.n205 VDPWR.n249 260.22450244106
RRED173 VDPWR.n205 VDPWR.n236 1693.2310888325
RRED174 VDPWR.n205 VDPWR.n238 25972.185227221
RRED175 VDPWR.n205 VDPWR.n204 20020.22611265
RRED176 VDPWR.n226 VDPWR.n218 202.20287778615
RRED177 VDPWR.n226 VDPWR.n213 127.6404483052
RRED178 VDPWR.n226 VDPWR.n212 584.20267284268
RRED179 VDPWR.n226 VDPWR.n234 705.46176839388
RRED180 VDPWR.n226 VDPWR.n209 2950.2530076068
RRED181 VDPWR.n226 VDPWR.n241 903.68287547011
RRED182 VDPWR.n226 VDPWR.n232 4148.1938634048
RRED183 VDPWR.n218 VDPWR.n212 1526.0827722068
RRED184 VDPWR.n218 VDPWR.n234 473.41749234025
RRED185 VDPWR.n218 VDPWR.n209 3139.3180929504
RRED186 VDPWR.n218 VDPWR.n241 781.42628371416
RRED187 VDPWR.n218 VDPWR.n232 5449.4074141582
RRED188 VDPWR.n218 VDPWR.n213 2841.9232494736
RRED189 VDPWR.n297 VDPWR.n257 246.38075589636
RRED190 VDPWR.n297 VDPWR.n256 123.29691371344
RRED191 VDPWR.n297 VDPWR.n301 979.74449246634
RRED192 VDPWR.n297 VDPWR.n293 652.18065068966
RRED193 VDPWR.n297 VDPWR.n261 11337.578664155
RRED194 VDPWR.n297 VDPWR.n291 8739.3835536196
RRED195 VDPWR.n297 VDPWR.n288 525.60868656433
RRED196 VDPWR.n297 VDPWR.n290 2995.5550561079
RRED197 VDPWR.n257 VDPWR.n301 260.22450244106
RRED198 VDPWR.n257 VDPWR.n288 1693.2310888325
RRED199 VDPWR.n257 VDPWR.n290 25972.185227221
RRED200 VDPWR.n257 VDPWR.n256 20020.22611265
RRED201 VDPWR.n278 VDPWR.n270 202.20287778615
RRED202 VDPWR.n278 VDPWR.n265 127.6404483052
RRED203 VDPWR.n278 VDPWR.n264 584.20267284268
RRED204 VDPWR.n278 VDPWR.n286 705.46176839388
RRED205 VDPWR.n278 VDPWR.n261 2950.2530076068
RRED206 VDPWR.n278 VDPWR.n293 903.68287547011
RRED207 VDPWR.n278 VDPWR.n284 4148.1938634048
RRED208 VDPWR.n270 VDPWR.n264 1526.0827722068
RRED209 VDPWR.n270 VDPWR.n286 473.41749234025
RRED210 VDPWR.n270 VDPWR.n261 3139.3180929504
RRED211 VDPWR.n270 VDPWR.n293 781.42628371416
RRED212 VDPWR.n270 VDPWR.n284 5449.4074141582
RRED213 VDPWR.n270 VDPWR.n265 2841.9232494736
RRED214 VDPWR.n157 VDPWR.n162 185
RRED215 VDPWR.n157 VDPWR.n189 158.01752996311
RRED216 VDPWR.n157 VDPWR.n180 671.09330220048
RRED217 VDPWR.n157 VDPWR.n187 805.3797524936
RRED218 VDPWR.n157 VDPWR.n152 3339.1848440543
RRED219 VDPWR.n157 VDPWR.n197 18748.826204484
RRED220 VDPWR.n157 VDPWR.n160 23320.29450107
RRED221 VDPWR.n157 VDPWR.n182 5636.7260697592
RRED222 VDPWR.n157 VDPWR.n161 1794.4244416887
RRED223 VDPWR.n186 VDPWR.n187 185
RRED224 VDPWR.n186 VDPWR.n152 800.55894420126
RRED225 VDPWR.n186 VDPWR.n184 195.95624492129
RRED226 VDPWR.n186 VDPWR.n182 384.87558611479
RRED227 VDPWR.n186 VDPWR.n162 752.06676427935
RRED228 VDPWR.n186 VDPWR.n160 4482.7354247768
RRED229 VDPWR.n186 VDPWR.n180 3455.4418899321
RRED230 VDPWR.n186 VDPWR.n197 12289.076128618
RRED231 VDPWR.n160 VDPWR.n161 183.55648051341
RRED232 VDPWR.n160 VDPWR.n182 157.15976085553
RRED233 VDPWR.n160 VDPWR.n180 793.38307140902
RRED234 VDPWR.n160 VDPWR.n162 3629.0725753549
RRED235 VDPWR.n160 VDPWR.n184 12965.491956379
RRED236 VDPWR.n160 VDPWR.n189 5672.4154589695
RRED237 VDPWR.n209 VDPWR.n214 185
RRED238 VDPWR.n209 VDPWR.n241 158.01752996311
RRED239 VDPWR.n209 VDPWR.n232 671.09330220048
RRED240 VDPWR.n209 VDPWR.n239 805.3797524936
RRED241 VDPWR.n209 VDPWR.n204 3339.1848440543
RRED242 VDPWR.n209 VDPWR.n249 18748.826204484
RRED243 VDPWR.n209 VDPWR.n212 23320.29450107
RRED244 VDPWR.n209 VDPWR.n234 5636.7260697592
RRED245 VDPWR.n209 VDPWR.n213 1794.4244416887
RRED246 VDPWR.n238 VDPWR.n239 185
RRED247 VDPWR.n238 VDPWR.n204 800.55894420126
RRED248 VDPWR.n238 VDPWR.n236 195.95624492129
RRED249 VDPWR.n238 VDPWR.n234 384.87558611479
RRED250 VDPWR.n238 VDPWR.n214 752.06676427935
RRED251 VDPWR.n238 VDPWR.n212 4482.7354247768
RRED252 VDPWR.n238 VDPWR.n232 3455.4418899321
RRED253 VDPWR.n238 VDPWR.n249 12289.076128618
RRED254 VDPWR.n212 VDPWR.n213 183.55648051341
RRED255 VDPWR.n212 VDPWR.n234 157.15976085553
RRED256 VDPWR.n212 VDPWR.n232 793.38307140902
RRED257 VDPWR.n212 VDPWR.n214 3629.0725753549
RRED258 VDPWR.n212 VDPWR.n236 12965.491956379
RRED259 VDPWR.n212 VDPWR.n241 5672.4154589695
RRED260 VDPWR.n261 VDPWR.n266 185
RRED261 VDPWR.n261 VDPWR.n293 158.01752996311
RRED262 VDPWR.n261 VDPWR.n284 671.09330220048
RRED263 VDPWR.n261 VDPWR.n291 805.3797524936
RRED264 VDPWR.n261 VDPWR.n256 3339.1848440543
RRED265 VDPWR.n261 VDPWR.n301 18748.826204484
RRED266 VDPWR.n261 VDPWR.n264 23320.29450107
RRED267 VDPWR.n261 VDPWR.n286 5636.7260697592
RRED268 VDPWR.n261 VDPWR.n265 1794.4244416887
RRED269 VDPWR.n290 VDPWR.n291 185
RRED270 VDPWR.n290 VDPWR.n256 800.55894420126
RRED271 VDPWR.n290 VDPWR.n288 195.95624492129
RRED272 VDPWR.n290 VDPWR.n286 384.87558611479
RRED273 VDPWR.n290 VDPWR.n266 752.06676427935
RRED274 VDPWR.n290 VDPWR.n264 4482.7354247768
RRED275 VDPWR.n290 VDPWR.n284 3455.4418899321
RRED276 VDPWR.n290 VDPWR.n301 12289.076128618
RRED277 VDPWR.n264 VDPWR.n265 183.55648051341
RRED278 VDPWR.n264 VDPWR.n286 157.15976085553
RRED279 VDPWR.n264 VDPWR.n284 793.38307140902
RRED280 VDPWR.n264 VDPWR.n266 3629.0725753549
RRED281 VDPWR.n264 VDPWR.n288 12965.491956379
RRED282 VDPWR.n264 VDPWR.n293 5672.4154589695
RRED283 VDPWR.n304 VDPWR.n354 185
RRED284 VDPWR.n304 VDPWR.n407 146.58597558662
RRED285 VDPWR.n304 VDPWR.n355 709.43819716983
RRED286 VDPWR.n304 VDPWR.n404 786.43886272734
RRED287 VDPWR.n304 VDPWR.n306 3085.5708975354
RRED288 VDPWR.n304 VDPWR.n398 10890.729552547
RRED289 VDPWR.n304 VDPWR.n373 8320.1166120171
RRED290 VDPWR.n304 VDPWR.n348 4145.1282468842
RRED291 VDPWR.n304 VDPWR.n315 2635.3910446669
RRED292 VDPWR.n304 VDPWR.n345 32230.510975419
RRED293 VDPWR.n304 VDPWR.n311 2111.7380492276
RRED294 VDPWR.n308 VDPWR.n306 185
RRED295 VDPWR.n308 VDPWR.n400 161.18322035327
RRED296 VDPWR.n308 VDPWR.n398 800.42373770673
RRED297 VDPWR.n308 VDPWR.n404 680.51383014618
RRED298 VDPWR.n308 VDPWR.n397 2986.880910864
RRED299 VDPWR.n308 VDPWR.n345 2255.8038376875
RRED300 VDPWR.n308 VDPWR.n355 3986.2768034373
RRED301 VDPWR.n308 VDPWR.n311 7513.0459939237
RRED302 VDPWR.n308 VDPWR.n354 1926.626167413
RRED303 VDPWR.n308 VDPWR.n396 10745.717726852
RRED304 VDPWR.n308 VDPWR.n373 202858.74022921
RRED305 VDPWR.n410 VDPWR.n460 185
RRED306 VDPWR.n410 VDPWR.n514 146.58034628447
RRED307 VDPWR.n410 VDPWR.n461 709.42455304527
RRED308 VDPWR.n410 VDPWR.n511 786.43886272734
RRED309 VDPWR.n410 VDPWR.n412 3085.5708975354
RRED310 VDPWR.n410 VDPWR.n505 10890.729552547
RRED311 VDPWR.n410 VDPWR.n479 8320.1166120171
RRED312 VDPWR.n410 VDPWR.n454 4143.8117284304
RRED313 VDPWR.n410 VDPWR.n421 2541.4366615592
RRED314 VDPWR.n410 VDPWR.n452 63202.202255594
RRED315 VDPWR.n410 VDPWR.n417 2111.5117397208
RRED316 VDPWR.n414 VDPWR.n412 185
RRED317 VDPWR.n414 VDPWR.n509 157.66647619172
RRED318 VDPWR.n414 VDPWR.n505 665.27105233504
RRED319 VDPWR.n414 VDPWR.n511 805.95900106728
RRED320 VDPWR.n414 VDPWR.n504 1668.7925758769
RRED321 VDPWR.n414 VDPWR.n460 3385.5366320194
RRED322 VDPWR.n414 VDPWR.n461 13163.585165595
RRED323 VDPWR.n414 VDPWR.n452 10373.093173483
RRED324 VDPWR.n414 VDPWR.n417 49259.327962166
RRED325 VDPWR.n414 VDPWR.n503 1422.1013606376
RRED326 VDPWR.n414 VDPWR.n479 17851.398107057
RRED327 VDPWR.n527 VDPWR.n528 185
RRED328 VDPWR.n527 VDPWR.n594 180.14926660624
RRED329 VDPWR.n527 VDPWR.n585 716.8074139327
RRED330 VDPWR.n527 VDPWR.n592 808.62210291451
RRED331 VDPWR.n527 VDPWR.n581 536.34830911276
RRED332 VDPWR.n527 VDPWR.n521 3615.3381291972
RRED333 VDPWR.n527 VDPWR.n596 23973.415270908
RRED334 VDPWR.n527 VDPWR.n532 2552.9293932791
RRED335 VDPWR.n527 VDPWR.n535 15216.876442044
RRED336 VDPWR.n527 VDPWR.n579 11729.675590742
RRED337 VDPWR.n535 VDPWR.n536 185
RRED338 VDPWR.n535 VDPWR.n581 162.81243442431
RRED339 VDPWR.n535 VDPWR.n573 680.47599755678
RRED340 VDPWR.n535 VDPWR.n579 806.16703550364
RRED341 VDPWR.n535 VDPWR.n532 3402.4826584696
RRED342 VDPWR.n535 VDPWR.n585 14138.720887244
RRED343 VDPWR.n535 VDPWR.n594 12358.546288811
RRED344 VDPWR.n535 VDPWR.n558 2267.7322331218
RRED345 VDPWR.n535 VDPWR.n567 3983.1939330551
RRED346 VDPWR.n535 VDPWR.n544 7501.4267011771
RRED347 VDPWR.n535 VDPWR.n540 1926.1000145169
RRED348 VDPWR.n519 VDPWR.n521 185
RRED349 VDPWR.n519 VDPWR.n520 179.79653226339
RRED350 VDPWR.n519 VDPWR.n592 716.8074139327
RRED351 VDPWR.n519 VDPWR.n599 718.6037156012
RRED352 VDPWR.n519 VDPWR.n587 536.34830911276
RRED353 VDPWR.n519 VDPWR.n518 5839.9011945226
RRED354 VDPWR.n519 VDPWR.n605 10898.590271439
RRED355 VDPWR.n519 VDPWR.n528 2552.9293932791
RRED356 VDPWR.n519 VDPWR.n531 15216.876442044
RRED357 VDPWR.n519 VDPWR.n585 11729.675590742
RRED358 VDPWR.n519 VDPWR.n596 780055.98655604
RRED359 VDPWR.n531 VDPWR.n532 185
RRED360 VDPWR.n531 VDPWR.n587 179.12720470961
RRED361 VDPWR.n531 VDPWR.n579 716.8074139327
RRED362 VDPWR.n531 VDPWR.n585 806.16703550364
RRED363 VDPWR.n531 VDPWR.n575 536.34830911276
RRED364 VDPWR.n531 VDPWR.n528 3402.4826584696
RRED365 VDPWR.n531 VDPWR.n592 14138.720887244
RRED366 VDPWR.n531 VDPWR.n520 12358.546288811
RRED367 VDPWR.n531 VDPWR.n536 2552.9293932791
RRED368 VDPWR.n531 VDPWR.n539 15216.876442044
RRED369 VDPWR.n531 VDPWR.n573 11729.675590742
RRED370 VDPWR.n539 VDPWR.n540 185
RRED371 VDPWR.n539 VDPWR.n575 159.76453256746
RRED372 VDPWR.n539 VDPWR.n567 672.9064602401
RRED373 VDPWR.n539 VDPWR.n573 806.16703550364
RRED374 VDPWR.n539 VDPWR.n536 3402.4826584696
RRED375 VDPWR.n539 VDPWR.n579 14138.720887244
RRED376 VDPWR.n539 VDPWR.n587 12358.546288811
RRED377 VDPWR.n539 VDPWR.n561 3282.5242156095
RRED378 VDPWR.n539 VDPWR.n548 3602.5498557567
RRED379 VDPWR.n539 VDPWR.n558 2925.8901995911
RRED380 VDPWR.n539 VDPWR.n544 1817.6662316121
RRED381 VDPWR.n618 VDPWR.n619 185
RRED382 VDPWR.n618 VDPWR.n685 180.14926660624
RRED383 VDPWR.n618 VDPWR.n676 716.8074139327
RRED384 VDPWR.n618 VDPWR.n683 808.62210291451
RRED385 VDPWR.n618 VDPWR.n672 536.34830911276
RRED386 VDPWR.n618 VDPWR.n612 3615.3381291972
RRED387 VDPWR.n618 VDPWR.n687 23973.415270908
RRED388 VDPWR.n618 VDPWR.n623 2552.9293932791
RRED389 VDPWR.n618 VDPWR.n626 15216.876442044
RRED390 VDPWR.n618 VDPWR.n670 11729.675590742
RRED391 VDPWR.n626 VDPWR.n627 185
RRED392 VDPWR.n626 VDPWR.n672 162.81243442431
RRED393 VDPWR.n626 VDPWR.n664 680.47599755678
RRED394 VDPWR.n626 VDPWR.n670 806.16703550364
RRED395 VDPWR.n626 VDPWR.n623 3402.4826584696
RRED396 VDPWR.n626 VDPWR.n676 14138.720887244
RRED397 VDPWR.n626 VDPWR.n685 12358.546288811
RRED398 VDPWR.n626 VDPWR.n649 2267.7322331218
RRED399 VDPWR.n626 VDPWR.n658 3983.1939330551
RRED400 VDPWR.n626 VDPWR.n635 7501.4267011771
RRED401 VDPWR.n626 VDPWR.n631 1926.1000145169
RRED402 VDPWR.n610 VDPWR.n612 185
RRED403 VDPWR.n610 VDPWR.n611 179.79653226339
RRED404 VDPWR.n610 VDPWR.n683 716.8074139327
RRED405 VDPWR.n610 VDPWR.n690 718.6037156012
RRED406 VDPWR.n610 VDPWR.n678 536.34830911276
RRED407 VDPWR.n610 VDPWR.n609 5839.9011945226
RRED408 VDPWR.n610 VDPWR.n696 10898.590271439
RRED409 VDPWR.n610 VDPWR.n619 2552.9293932791
RRED410 VDPWR.n610 VDPWR.n622 15216.876442044
RRED411 VDPWR.n610 VDPWR.n676 11729.675590742
RRED412 VDPWR.n610 VDPWR.n687 780055.98655604
RRED413 VDPWR.n622 VDPWR.n623 185
RRED414 VDPWR.n622 VDPWR.n678 179.12720470961
RRED415 VDPWR.n622 VDPWR.n670 716.8074139327
RRED416 VDPWR.n622 VDPWR.n676 806.16703550364
RRED417 VDPWR.n622 VDPWR.n666 536.34830911276
RRED418 VDPWR.n622 VDPWR.n619 3402.4826584696
RRED419 VDPWR.n622 VDPWR.n683 14138.720887244
RRED420 VDPWR.n622 VDPWR.n611 12358.546288811
RRED421 VDPWR.n622 VDPWR.n627 2552.9293932791
RRED422 VDPWR.n622 VDPWR.n630 15216.876442044
RRED423 VDPWR.n622 VDPWR.n664 11729.675590742
RRED424 VDPWR.n630 VDPWR.n631 185
RRED425 VDPWR.n630 VDPWR.n666 159.76453256746
RRED426 VDPWR.n630 VDPWR.n658 672.9064602401
RRED427 VDPWR.n630 VDPWR.n664 806.16703550364
RRED428 VDPWR.n630 VDPWR.n627 3402.4826584696
RRED429 VDPWR.n630 VDPWR.n670 14138.720887244
RRED430 VDPWR.n630 VDPWR.n678 12358.546288811
RRED431 VDPWR.n630 VDPWR.n652 3282.5242156095
RRED432 VDPWR.n630 VDPWR.n639 3602.5498557567
RRED433 VDPWR.n630 VDPWR.n649 2925.8901995911
RRED434 VDPWR.n630 VDPWR.n635 1817.6662316121
RRED435 VDPWR.n900 VDPWR.n1081 185
RRED436 VDPWR.n900 VDPWR.n944 185.93072236172
RRED437 VDPWR.n900 VDPWR.n702 732.2092796877
RRED438 VDPWR.n900 VDPWR.n1080 720.22961378462
RRED439 VDPWR.n900 VDPWR.n1090 475.85434956295
RRED440 VDPWR.n900 VDPWR.n700 3834.722704469
RRED441 VDPWR.n900 VDPWR.n1087 2955.9320846948
RRED442 VDPWR.n900 VDPWR.n1079 4143.610569285
RRED443 VDPWR.n900 VDPWR.n1082 8252577398093.7
RRED444 VDPWR.n900 VDPWR.n1084 1994406924099.3
RRED445 VDPWR.n700 VDPWR.n893 185
RRED446 VDPWR.n700 VDPWR.n1090 167.08267323175
RRED447 VDPWR.n700 VDPWR.n708 895.87475252187
RRED448 VDPWR.n700 VDPWR.n894 791.9331196276
RRED449 VDPWR.n700 VDPWR.n889 968.57460039721
RRED450 VDPWR.n700 VDPWR.n1087 791.87821548687
RRED451 VDPWR.n700 VDPWR.n702 3389.8085705711
RRED452 VDPWR.n700 VDPWR.n944 4145.9087898835
RRED453 VDPWR.n708 VDPWR.n707 184.99999999816
RRED454 VDPWR.n708 VDPWR.n889 188.19169759535
RRED455 VDPWR.n708 VDPWR.n887 720.22961375346
RRED456 VDPWR.n708 VDPWR.n894 777.18173345677
RRED457 VDPWR.n708 VDPWR.n1090 556.22303102185
RRED458 VDPWR.n708 VDPWR.n711 4143.6106003197
RRED459 VDPWR.n708 VDPWR.n895 10391868362603
RRED460 VDPWR.n708 VDPWR.n897 2525883524884.6
RRED461 VDPWR.n1082 VDPWR.n1081 185
RRED462 VDPWR.n1082 VDPWR.n1084 158.77082032093
RRED463 VDPWR.n1082 VDPWR.n702 806.90654715502
RRED464 VDPWR.n1082 VDPWR.n1079 938.18037701778
RRED465 VDPWR.n1082 VDPWR.n1080 610.48649094987
RRED466 VDPWR.n1082 VDPWR.n1087 3464.0461919046
RRED467 VDPWR.n1082 VDPWR.n897 5054.8576486969
RRED468 VDPWR.n1082 VDPWR.n895 20647.638368109
RRED469 VDPWR.n1082 VDPWR.n893 15915.887908751
RRED470 VDPWR.n1082 VDPWR.n944 113874619501.35
RRED471 VDPWR.n895 VDPWR.n894 185
RRED472 VDPWR.n895 VDPWR.n893 806.90654715502
RRED473 VDPWR.n895 VDPWR.n897 160.07505173224
RRED474 VDPWR.n895 VDPWR.n707 665.5652619997
RRED475 VDPWR.n895 VDPWR.n1087 3464.0461919046
RRED476 VDPWR.n895 VDPWR.n1084 5054.8576486969
RRED477 VDPWR.n895 VDPWR.n702 15915.887908751
RRED478 VDPWR.n895 VDPWR.n711 1304.3519382627
RRED479 VDPWR.n895 VDPWR.n889 143393996687.62
RRED480 VDPWR.n895 VDPWR.n887 1673.0984679551
RRED481 VDPWR.n52 VDPWR.t12 219.619
RRED482 VDPWR.n52 VDPWR.n51 24.5469
RRED483 VDPWR.n52 VDPWR.n3 1.34261
RRED484 VDPWR.n3 VDPWR.t6 219.425
RRED485 VDPWR.n3 VDPWR.n99 24.5469
RRED486 VDPWR.n3 VDPWR.n2 1.72906
RRED487 VDPWR.n2 VDPWR.t8 219.425
RRED488 VDPWR.n2 VDPWR.n146 24.5469
RRED489 VDPWR.n2 VDPWR.n198 1.5515
RRED490 VDPWR.n4 VDPWR.t10 208.147
RRED491 VDPWR.n4 VDPWR.n1090 27.9844
RRED492 VDPWR.n4 VDPWR 12.7583
RRED493 VDPWR.n4 VDPWR.n697 2.31917
RRED494 VDPWR.n599 VDPWR.n518 189.09089936259
RRED495 VDPWR.n599 VDPWR.n521 109.123
RRED496 VDPWR.n599 VDPWR.n520 536.04065295081
RRED497 VDPWR.n599 VDPWR.n605 8400.9966675679
RRED498 VDPWR.n599 VDPWR.n596 601293.15630361
RRED499 VDPWR.n518 VDPWR.n605 138.01963739344
RRED500 VDPWR.n518 VDPWR.n596 266.47671492218
RRED501 VDPWR.n518 VDPWR.n520 654.10776786923
RRED502 VDPWR.n561 VDPWR.n548 176.72856012411
RRED503 VDPWR.n561 VDPWR.n544 101.91680352102
RRED504 VDPWR.n561 VDPWR.n558 2020.5866838405
RRED505 VDPWR.n561 VDPWR.n575 1034.9535947093
RRED506 VDPWR.n561 VDPWR.n567 4509.4829404911
RRED507 VDPWR.n548 VDPWR.n558 118.32056039325
RRED508 VDPWR.n548 VDPWR.n575 900.69545795494
RRED509 VDPWR.n548 VDPWR.n567 6219.2500260694
RRED510 VDPWR.n548 VDPWR.n544 3199.384215451
RRED511 VDPWR.n690 VDPWR.n609 189.09089936259
RRED512 VDPWR.n690 VDPWR.n612 109.123
RRED513 VDPWR.n690 VDPWR.n611 536.04065295081
RRED514 VDPWR.n690 VDPWR.n696 8400.9966675679
RRED515 VDPWR.n690 VDPWR.n687 601293.15630361
RRED516 VDPWR.n609 VDPWR.n696 138.01963739344
RRED517 VDPWR.n609 VDPWR.n687 266.47671492218
RRED518 VDPWR.n609 VDPWR.n611 654.10776786923
RRED519 VDPWR.n652 VDPWR.n639 176.72856012411
RRED520 VDPWR.n652 VDPWR.n635 101.91680352102
RRED521 VDPWR.n652 VDPWR.n649 2020.5866838405
RRED522 VDPWR.n652 VDPWR.n666 1034.9535947093
RRED523 VDPWR.n652 VDPWR.n658 4509.4829404911
RRED524 VDPWR.n639 VDPWR.n649 118.32056039325
RRED525 VDPWR.n639 VDPWR.n666 900.69545795494
RRED526 VDPWR.n639 VDPWR.n658 6219.2500260694
RRED527 VDPWR.n639 VDPWR.n635 3199.384215451
RRED528 VDPWR.n16 VDPWR.n27 124.87730781456
RRED529 VDPWR.n16 VDPWR.t11 42.0578
RRED530 VDPWR.n16 VDPWR.n48 702.48484124814
RRED531 VDPWR.n16 VDPWR.n51 379.27256188352
RRED532 VDPWR.n16 VDPWR.n9 1112.9971605655
RRED533 VDPWR.n48 VDPWR.n9 124.87731988839
RRED534 VDPWR.n48 VDPWR.t11 42.0578
RRED535 VDPWR.n48 VDPWR.n51 379.27247873265
RRED536 VDPWR.n48 VDPWR.n27 1112.997102522
RRED537 VDPWR.n9 VDPWR.n51 200.26999120383
RRED538 VDPWR.n9 VDPWR.n27 745.74292957555
RRED539 VDPWR.n27 VDPWR.n51 200.26979133252
RRED540 VDPWR.n64 VDPWR.n75 124.87730781456
RRED541 VDPWR.n64 VDPWR.t5 42.0578
RRED542 VDPWR.n64 VDPWR.n99 379.27256188352
RRED543 VDPWR.n64 VDPWR.n96 702.48484124814
RRED544 VDPWR.n64 VDPWR.n57 1112.9971605655
RRED545 VDPWR.n96 VDPWR.n57 124.87731988839
RRED546 VDPWR.n96 VDPWR.t5 42.0578
RRED547 VDPWR.n96 VDPWR.n99 379.27247873265
RRED548 VDPWR.n96 VDPWR.n75 1112.997102522
RRED549 VDPWR.n57 VDPWR.n99 200.26999120383
RRED550 VDPWR.n57 VDPWR.n75 745.74292957555
RRED551 VDPWR.n75 VDPWR.n99 200.26979133252
RRED552 VDPWR.n111 VDPWR.n122 124.87730781456
RRED553 VDPWR.n111 VDPWR.t7 42.0578
RRED554 VDPWR.n111 VDPWR.n146 379.27256188352
RRED555 VDPWR.n111 VDPWR.n143 702.48484124814
RRED556 VDPWR.n111 VDPWR.n104 1112.9971605655
RRED557 VDPWR.n143 VDPWR.n104 124.87731988839
RRED558 VDPWR.n143 VDPWR.t7 42.0578
RRED559 VDPWR.n143 VDPWR.n146 379.27247873265
RRED560 VDPWR.n143 VDPWR.n122 1112.997102522
RRED561 VDPWR.n104 VDPWR.n146 200.26999120383
RRED562 VDPWR.n104 VDPWR.n122 745.74292957555
RRED563 VDPWR.n122 VDPWR.n146 200.26979133252
RRED564 VDPWR.n197 VDPWR.n198 24.5469
RRED565 VDPWR.n197 VDPWR.n184 147.30336497864
RRED566 VDPWR.n197 VDPWR.n189 206.75552730233
RRED567 VDPWR.n197 VDPWR.n152 2361.3796004786
RRED568 VDPWR.n197 VDPWR.n187 14452.22019929
RRED569 VDPWR.n152 VDPWR.n187 132.62244560154
RRED570 VDPWR.n152 VDPWR.n184 515.37947802732
RRED571 VDPWR.n152 VDPWR.n189 520.97263099107
RRED572 VDPWR.n184 VDPWR.n182 88.427532371832
RRED573 VDPWR.n184 VDPWR.n162 2175.2155010151
RRED574 VDPWR.n184 VDPWR.n180 9994.2333830425
RRED575 VDPWR.n187 VDPWR.t0 65.8014
RRED576 VDPWR.n187 VDPWR.n189 514.40256872876
RRED577 VDPWR.n162 VDPWR.n180 133.17054388302
RRED578 VDPWR.n162 VDPWR.t0 74.0265
RRED579 VDPWR.n162 VDPWR.n182 745.96814378967
RRED580 VDPWR.n180 VDPWR.n161 130.43001326997
RRED581 VDPWR.n180 VDPWR.n182 521.60748234593
RRED582 VDPWR.n180 VDPWR.n189 892.57459126975
RRED583 VDPWR.n182 VDPWR.n189 1370.4227149678
RRED584 VDPWR.n182 VDPWR.n161 5699.6438428001
RRED585 VDPWR.n161 VDPWR.n189 864.29825799442
RRED586 VDPWR.n249 VDPWR.n250 24.5469
RRED587 VDPWR.n249 VDPWR.n236 147.30336497864
RRED588 VDPWR.n249 VDPWR.n241 206.75552730233
RRED589 VDPWR.n249 VDPWR.n204 2361.3796004786
RRED590 VDPWR.n249 VDPWR.n239 14452.22019929
RRED591 VDPWR.n204 VDPWR.n239 132.62244560154
RRED592 VDPWR.n204 VDPWR.n236 515.37947802732
RRED593 VDPWR.n204 VDPWR.n241 520.97263099107
RRED594 VDPWR.n236 VDPWR.n234 88.427532371832
RRED595 VDPWR.n236 VDPWR.n214 2175.2155010151
RRED596 VDPWR.n236 VDPWR.n232 9994.2333830425
RRED597 VDPWR.n239 VDPWR.t4 65.8014
RRED598 VDPWR.n239 VDPWR.n241 514.40256872876
RRED599 VDPWR.n214 VDPWR.n232 133.17054388302
RRED600 VDPWR.n214 VDPWR.t4 74.0265
RRED601 VDPWR.n214 VDPWR.n234 745.96814378967
RRED602 VDPWR.n232 VDPWR.n213 130.43001326997
RRED603 VDPWR.n232 VDPWR.n234 521.60748234593
RRED604 VDPWR.n232 VDPWR.n241 892.57459126975
RRED605 VDPWR.n234 VDPWR.n241 1370.4227149678
RRED606 VDPWR.n234 VDPWR.n213 5699.6438428001
RRED607 VDPWR.n213 VDPWR.n241 864.29825799442
RRED608 VDPWR.n301 VDPWR.n0 24.5469
RRED609 VDPWR.n301 VDPWR.n288 147.30336497864
RRED610 VDPWR.n301 VDPWR.n293 206.75552730233
RRED611 VDPWR.n301 VDPWR.n256 2361.3796004786
RRED612 VDPWR.n301 VDPWR.n291 14452.22019929
RRED613 VDPWR.n256 VDPWR.n291 132.62244560154
RRED614 VDPWR.n256 VDPWR.n288 515.37947802732
RRED615 VDPWR.n256 VDPWR.n293 520.97263099107
RRED616 VDPWR.n288 VDPWR.n286 88.427532371832
RRED617 VDPWR.n288 VDPWR.n266 2175.2155010151
RRED618 VDPWR.n288 VDPWR.n284 9994.2333830425
RRED619 VDPWR.n291 VDPWR.t1 65.8014
RRED620 VDPWR.n291 VDPWR.n293 514.40256872876
RRED621 VDPWR.n266 VDPWR.n284 133.17054388302
RRED622 VDPWR.n266 VDPWR.t1 74.0265
RRED623 VDPWR.n266 VDPWR.n286 745.96814378967
RRED624 VDPWR.n284 VDPWR.n265 130.43001326997
RRED625 VDPWR.n284 VDPWR.n286 521.60748234593
RRED626 VDPWR.n284 VDPWR.n293 892.57459126975
RRED627 VDPWR.n286 VDPWR.n293 1370.4227149678
RRED628 VDPWR.n286 VDPWR.n265 5699.6438428001
RRED629 VDPWR.n265 VDPWR.n293 864.29825799442
RRED630 VDPWR.n348 VDPWR.n315 79.10388880929
RRED631 VDPWR.n348 VDPWR.n311 53.422426716396
RRED632 VDPWR.n348 VDPWR.n345 16420.678909776
RRED633 VDPWR.n348 VDPWR.n407 868.12123419547
RRED634 VDPWR.n348 VDPWR.n355 4771.6609014365
RRED635 VDPWR.n311 VDPWR.n355 52.382664006871
RRED636 VDPWR.n311 VDPWR.n345 1512.1281661431
RRED637 VDPWR.n311 VDPWR.n407 753.71606416546
RRED638 VDPWR.n311 VDPWR.n315 1889.2864980877
RRED639 VDPWR.n311 VDPWR.n400 2023.4407648824
RRED640 VDPWR.n311 VDPWR.n404 11911.60313415
RRED641 VDPWR.n311 VDPWR.n354 5101.903421151
RRED642 VDPWR.n355 VDPWR.n354 53.6669900508
RRED643 VDPWR.n355 VDPWR.n407 776.30311995671
RRED644 VDPWR.n355 VDPWR.n345 1649.1928290133
RRED645 VDPWR.n355 VDPWR.n315 3728.1893270597
RRED646 VDPWR.n355 VDPWR.n400 1282.8915151902
RRED647 VDPWR.n355 VDPWR.n404 5390.6651876637
RRED648 VDPWR.n354 VDPWR.t14 27.6546
RRED649 VDPWR.n354 VDPWR.n404 2030.9753991958
RRED650 VDPWR.n354 VDPWR.n400 991.95373476238
RRED651 VDPWR.n354 VDPWR.n345 2341.5845715516
RRED652 VDPWR.n404 VDPWR.n306 54.051780571201
RRED653 VDPWR.n404 VDPWR.t14 27.6546
RRED654 VDPWR.n404 VDPWR.n400 963.80031245173
RRED655 VDPWR.n404 VDPWR.n398 8394.9373634214
RRED656 VDPWR.n404 VDPWR.n373 6413.4232217632
RRED657 VDPWR.n404 VDPWR.n407 613.49236174182
RRED658 VDPWR.n404 VDPWR.n345 4063.7709722756
RRED659 VDPWR.n306 VDPWR.n398 53.947972901358
RRED660 VDPWR.n306 VDPWR.n373 2703.801206589
RRED661 VDPWR.n306 VDPWR.n407 653.48447740541
RRED662 VDPWR.n398 VDPWR.n397 54.01122475025
RRED663 VDPWR.n398 VDPWR.n400 506.63174902852
RRED664 VDPWR.n398 VDPWR.n373 2040.1060808666
RRED665 VDPWR.n398 VDPWR.n407 983.52660243856
RRED666 VDPWR.n398 VDPWR.n396 8283.1574144488
RRED667 VDPWR.n397 VDPWR.n396 81.540160144087
RRED668 VDPWR.n397 VDPWR.n400 486.26638386618
RRED669 VDPWR.n397 VDPWR.n373 34033.531295807
RRED670 VDPWR.n396 VDPWR.n373 90.159358246995
RRED671 VDPWR.n396 VDPWR.n400 210.75602697606
RRED672 VDPWR.n373 VDPWR.n407 259.01496301046
RRED673 VDPWR.n373 VDPWR.n400 2516.9589762056
RRED674 VDPWR.n400 VDPWR.n345 545.63076944102
RRED675 VDPWR.n345 VDPWR.n315 89.594077504316
RRED676 VDPWR.n345 VDPWR.n407 4800.6342073643
RRED677 VDPWR.n315 VDPWR.n407 400.66592013022
RRED678 VDPWR.n454 VDPWR.n421 78.931975718219
RRED679 VDPWR.n454 VDPWR.n417 53.422142181704
RRED680 VDPWR.n454 VDPWR.n452 32199.989228069
RRED681 VDPWR.n454 VDPWR.n514 867.73363553737
RRED682 VDPWR.n454 VDPWR.n461 4770.4488522095
RRED683 VDPWR.n417 VDPWR.n461 52.613400613688
RRED684 VDPWR.n417 VDPWR.n452 772.51032740666
RRED685 VDPWR.n417 VDPWR.n509 1736.2405064643
RRED686 VDPWR.n417 VDPWR.n460 8264.2181348291
RRED687 VDPWR.n417 VDPWR.n511 37970.731970836
RRED688 VDPWR.n417 VDPWR.n514 753.52254942877
RRED689 VDPWR.n417 VDPWR.n421 1826.3472783124
RRED690 VDPWR.n461 VDPWR.n460 53.957384180468
RRED691 VDPWR.n461 VDPWR.n514 776.19345411868
RRED692 VDPWR.n461 VDPWR.n452 935.45461890157
RRED693 VDPWR.n461 VDPWR.n509 857.06148213897
RRED694 VDPWR.n461 VDPWR.n511 10146.930231813
RRED695 VDPWR.n461 VDPWR.n421 3597.495192635
RRED696 VDPWR.n460 VDPWR.t2 27.6546
RRED697 VDPWR.n460 VDPWR.n509 579.86182363663
RRED698 VDPWR.n460 VDPWR.n511 2609.6844871816
RRED699 VDPWR.n460 VDPWR.n452 1740.2897738356
RRED700 VDPWR.n511 VDPWR.n412 54.051780571201
RRED701 VDPWR.n511 VDPWR.t2 27.6546
RRED702 VDPWR.n511 VDPWR.n509 525.87983950509
RRED703 VDPWR.n511 VDPWR.n505 8394.9373634214
RRED704 VDPWR.n511 VDPWR.n479 6413.4232217632
RRED705 VDPWR.n511 VDPWR.n514 613.49236174182
RRED706 VDPWR.n511 VDPWR.n452 7995.9259878935
RRED707 VDPWR.n412 VDPWR.n505 53.947972901358
RRED708 VDPWR.n412 VDPWR.n479 2703.801206589
RRED709 VDPWR.n412 VDPWR.n514 653.48447740541
RRED710 VDPWR.n505 VDPWR.n504 53.637795775828
RRED711 VDPWR.n505 VDPWR.n479 1941.4700996379
RRED712 VDPWR.n505 VDPWR.n509 873.38603465566
RRED713 VDPWR.n505 VDPWR.n514 983.52660243856
RRED714 VDPWR.n505 VDPWR.n503 2391.5938779837
RRED715 VDPWR.n504 VDPWR.n503 79.53073482787
RRED716 VDPWR.n504 VDPWR.n509 838.27803389776
RRED717 VDPWR.n504 VDPWR.n479 18073.770773013
RRED718 VDPWR.n479 VDPWR.n503 89.675502673099
RRED719 VDPWR.n479 VDPWR.n514 259.01496301046
RRED720 VDPWR.n479 VDPWR.n509 4338.9973875151
RRED721 VDPWR.n503 VDPWR.n509 363.32385533467
RRED722 VDPWR.n509 VDPWR.n452 121.33826880983
RRED723 VDPWR.n452 VDPWR.n421 175.68892677846
RRED724 VDPWR.n452 VDPWR.n514 9413.7718466655
RRED725 VDPWR.n421 VDPWR.n514 386.09656070009
RRED726 VDPWR.n596 VDPWR.n605 52.07515475516
RRED727 VDPWR.n596 VDPWR.n594 163.50401219357
RRED728 VDPWR.n596 VDPWR.n521 4022.0104786608
RRED729 VDPWR.n596 VDPWR.n592 18479.507604658
RRED730 VDPWR.n596 VDPWR.n520 53351.665301177
RRED731 VDPWR.n605 VDPWR.n1 24.8594
RRED732 VDPWR.n605 VDPWR.n520 147.67109364088
RRED733 VDPWR.n520 VDPWR.n587 128.17192738228
RRED734 VDPWR.n520 VDPWR.n592 1371.3154487478
RRED735 VDPWR.n520 VDPWR.n528 2073.388464385
RRED736 VDPWR.n520 VDPWR.n585 9526.3794309582
RRED737 VDPWR.n521 VDPWR.n592 105.01110407785
RRED738 VDPWR.n521 VDPWR.n594 669.33258631297
RRED739 VDPWR.n592 VDPWR.n528 104.32372144677
RRED740 VDPWR.n592 VDPWR.n594 540.1310960668
RRED741 VDPWR.n592 VDPWR.n587 982.1934805296
RRED742 VDPWR.n592 VDPWR.n585 10898.597350584
RRED743 VDPWR.n528 VDPWR.n585 104.76414364359
RRED744 VDPWR.n528 VDPWR.n587 594.2435843762
RRED745 VDPWR.n585 VDPWR.n532 104.32372144677
RRED746 VDPWR.n585 VDPWR.n587 528.40406713884
RRED747 VDPWR.n585 VDPWR.n594 1371.3154487478
RRED748 VDPWR.n585 VDPWR.n581 982.1934805296
RRED749 VDPWR.n585 VDPWR.n579 10898.597350584
RRED750 VDPWR.n587 VDPWR.n575 128.17192738228
RRED751 VDPWR.n587 VDPWR.n579 1371.3154487478
RRED752 VDPWR.n587 VDPWR.n536 2073.388464385
RRED753 VDPWR.n587 VDPWR.n573 9526.3794309582
RRED754 VDPWR.n532 VDPWR.t13 51.3519
RRED755 VDPWR.n532 VDPWR.n581 594.2435843762
RRED756 VDPWR.n532 VDPWR.n579 2622.747049237
RRED757 VDPWR.n532 VDPWR.n594 2073.388464385
RRED758 VDPWR.n579 VDPWR.n536 104.32372144677
RRED759 VDPWR.n579 VDPWR.t13 57.7708
RRED760 VDPWR.n579 VDPWR.n581 528.40406713884
RRED761 VDPWR.n579 VDPWR.n575 982.1934805296
RRED762 VDPWR.n579 VDPWR.n594 9526.3794309582
RRED763 VDPWR.n579 VDPWR.n573 10898.597350584
RRED764 VDPWR.n536 VDPWR.n573 104.76414364359
RRED765 VDPWR.n536 VDPWR.n575 594.2435843762
RRED766 VDPWR.n573 VDPWR.n540 103.55800563936
RRED767 VDPWR.n573 VDPWR.n575 528.40406713884
RRED768 VDPWR.n573 VDPWR.n581 963.48665793495
RRED769 VDPWR.n573 VDPWR.n558 4085.2596612751
RRED770 VDPWR.n573 VDPWR.n567 5387.5350680248
RRED771 VDPWR.n573 VDPWR.n544 11895.387248103
RRED772 VDPWR.n575 VDPWR.n567 905.90244110602
RRED773 VDPWR.n575 VDPWR.n558 711.37596255995
RRED774 VDPWR.n575 VDPWR.n544 886.64504362946
RRED775 VDPWR.n540 VDPWR.n567 102.9097961538
RRED776 VDPWR.n540 VDPWR.n581 991.37727562075
RRED777 VDPWR.n540 VDPWR.n544 5096.7388308824
RRED778 VDPWR.n540 VDPWR.n558 2353.9665642789
RRED779 VDPWR.n567 VDPWR.n544 98.133504411329
RRED780 VDPWR.n567 VDPWR.n558 1294.0693824813
RRED781 VDPWR.n567 VDPWR.n581 1281.5717650931
RRED782 VDPWR.n544 VDPWR.n558 1046.2819579935
RRED783 VDPWR.n544 VDPWR.n581 2019.9569516575
RRED784 VDPWR.n558 VDPWR.n581 548.51599353289
RRED785 VDPWR.n581 VDPWR.n594 128.17192738228
RRED786 VDPWR.n687 VDPWR.n696 52.07515475516
RRED787 VDPWR.n687 VDPWR.n685 163.50401219357
RRED788 VDPWR.n687 VDPWR.n612 4022.0104786608
RRED789 VDPWR.n687 VDPWR.n683 18479.507604658
RRED790 VDPWR.n687 VDPWR.n611 53351.665301177
RRED791 VDPWR.n696 VDPWR.n697 24.8594
RRED792 VDPWR.n696 VDPWR.n611 147.67109364088
RRED793 VDPWR.n611 VDPWR.n678 128.17192738228
RRED794 VDPWR.n611 VDPWR.n683 1371.3154487478
RRED795 VDPWR.n611 VDPWR.n619 2073.388464385
RRED796 VDPWR.n611 VDPWR.n676 9526.3794309582
RRED797 VDPWR.n612 VDPWR.n683 105.01110407785
RRED798 VDPWR.n612 VDPWR.n685 669.33258631297
RRED799 VDPWR.n683 VDPWR.n619 104.32372144677
RRED800 VDPWR.n683 VDPWR.n685 540.1310960668
RRED801 VDPWR.n683 VDPWR.n678 982.1934805296
RRED802 VDPWR.n683 VDPWR.n676 10898.597350584
RRED803 VDPWR.n619 VDPWR.n676 104.76414364359
RRED804 VDPWR.n619 VDPWR.n678 594.2435843762
RRED805 VDPWR.n676 VDPWR.n623 104.32372144677
RRED806 VDPWR.n676 VDPWR.n678 528.40406713884
RRED807 VDPWR.n676 VDPWR.n685 1371.3154487478
RRED808 VDPWR.n676 VDPWR.n672 982.1934805296
RRED809 VDPWR.n676 VDPWR.n670 10898.597350584
RRED810 VDPWR.n678 VDPWR.n666 128.17192738228
RRED811 VDPWR.n678 VDPWR.n670 1371.3154487478
RRED812 VDPWR.n678 VDPWR.n627 2073.388464385
RRED813 VDPWR.n678 VDPWR.n664 9526.3794309582
RRED814 VDPWR.n623 VDPWR.t16 51.3519
RRED815 VDPWR.n623 VDPWR.n672 594.2435843762
RRED816 VDPWR.n623 VDPWR.n670 2622.747049237
RRED817 VDPWR.n623 VDPWR.n685 2073.388464385
RRED818 VDPWR.n670 VDPWR.n627 104.32372144677
RRED819 VDPWR.n670 VDPWR.t16 57.7708
RRED820 VDPWR.n670 VDPWR.n672 528.40406713884
RRED821 VDPWR.n670 VDPWR.n666 982.1934805296
RRED822 VDPWR.n670 VDPWR.n685 9526.3794309582
RRED823 VDPWR.n670 VDPWR.n664 10898.597350584
RRED824 VDPWR.n627 VDPWR.n664 104.76414364359
RRED825 VDPWR.n627 VDPWR.n666 594.2435843762
RRED826 VDPWR.n664 VDPWR.n631 103.55800563936
RRED827 VDPWR.n664 VDPWR.n666 528.40406713884
RRED828 VDPWR.n664 VDPWR.n672 963.48665793495
RRED829 VDPWR.n664 VDPWR.n649 4085.2596612751
RRED830 VDPWR.n664 VDPWR.n658 5387.5350680248
RRED831 VDPWR.n664 VDPWR.n635 11895.387248103
RRED832 VDPWR.n666 VDPWR.n658 905.90244110602
RRED833 VDPWR.n666 VDPWR.n649 711.37596255995
RRED834 VDPWR.n666 VDPWR.n635 886.64504362946
RRED835 VDPWR.n631 VDPWR.n658 102.9097961538
RRED836 VDPWR.n631 VDPWR.n672 991.37727562075
RRED837 VDPWR.n631 VDPWR.n635 5096.7388308824
RRED838 VDPWR.n631 VDPWR.n649 2353.9665642789
RRED839 VDPWR.n658 VDPWR.n635 98.133504411329
RRED840 VDPWR.n658 VDPWR.n649 1294.0693824813
RRED841 VDPWR.n658 VDPWR.n672 1281.5717650931
RRED842 VDPWR.n635 VDPWR.n649 1046.2819579935
RRED843 VDPWR.n635 VDPWR.n672 2019.9569516575
RRED844 VDPWR.n649 VDPWR.n672 548.51599353289
RRED845 VDPWR.n672 VDPWR.n685 128.17192738228
RRED846 VDPWR.n887 VDPWR.n711 18.849206759143
RRED847 VDPWR.n887 VDPWR.n707 12.413309661348
RRED848 VDPWR.n887 VDPWR.n889 525.58325182339
RRED849 VDPWR.n887 VDPWR.n897 840.87565555718
RRED850 VDPWR.n889 VDPWR.n711 159.09288360039
RRED851 VDPWR.n889 VDPWR.n1090 112.79387959289
RRED852 VDPWR.n889 VDPWR.n894 1839.6607448913
RRED853 VDPWR.n889 VDPWR.n897 34853841596.384
RRED854 VDPWR.n889 VDPWR.n707 256647795628.06
RRED855 VDPWR.n707 VDPWR.n894 12.5005
RRED856 VDPWR.n707 VDPWR.n897 875.04351750322
RRED857 VDPWR.n707 VDPWR.n711 2201.5711461983
RRED858 VDPWR.n894 VDPWR.n893 12.5005
RRED859 VDPWR.n894 VDPWR.n1090 1349.992625422
RRED860 VDPWR.n893 VDPWR.t9 6.2505
RRED861 VDPWR.n893 VDPWR.n897 560.89156628032
RRED862 VDPWR.n893 VDPWR.n1087 2670.2022729264
RRED863 VDPWR.n893 VDPWR.n1084 3896.4527708706
RRED864 VDPWR.n893 VDPWR.n702 12268.496929662
RRED865 VDPWR.n1087 VDPWR.n702 12.383286170151
RRED866 VDPWR.n1087 VDPWR.t9 6.2505
RRED867 VDPWR.n1087 VDPWR.n1090 680.08093193919
RRED868 VDPWR.n1087 VDPWR.n944 3195.8046922019
RRED869 VDPWR.n1087 VDPWR.n1084 848.05148542477
RRED870 VDPWR.n1087 VDPWR.n897 848.05148542477
RRED871 VDPWR.n702 VDPWR.n1081 12.5005
RRED872 VDPWR.n702 VDPWR.n1084 560.89156628032
RRED873 VDPWR.n702 VDPWR.n1090 922.30372272001
RRED874 VDPWR.n702 VDPWR.n944 1621.5969115936
RRED875 VDPWR.n702 VDPWR.n897 3896.4527708706
RRED876 VDPWR.n1081 VDPWR.n1080 12.5005
RRED877 VDPWR.n1080 VDPWR.n1079 18.929703818584
RRED878 VDPWR.n1080 VDPWR.n944 525.58325302595
RRED879 VDPWR.n1080 VDPWR.n1084 876.10828634081
RRED880 VDPWR.n944 VDPWR.n1090 109.33046266984
RRED881 VDPWR.n944 VDPWR.n1079 159.09288028578
RRED882 VDPWR.n944 VDPWR.n1084 27520169597.575
RRED883 VDPWR.n1079 VDPWR.n1084 265.19603263251
RRED884 VDPWR.n1084 VDPWR.n897 52.42451922223
RRED885 VDPWR.n897 VDPWR.n711 332.21917019822
RRED886 VDPWR.n0 VDPWR.t15 75.4926
RRED887 VDPWR.n0 VDPWR.n407 24.8594
RRED888 VDPWR.n0 VDPWR.n250 1.5515
RRED889 VDPWR.n0 VDPWR.n1 1.5045
RRED890 VDPWR.n1 VDPWR.t3 75.4926
RRED891 VDPWR.n1 VDPWR.n514 24.8594
RRED892 VDPWR.n1 VDPWR.n697 1.53583
RRED893 VDPWR.n198 VDPWR.n250 1.5515
RRED894 VGND.n40 VGND.t30 35397.101106162
RRED895 VGND.n40 VGND.t28 81667.861362448
RRED896 VGND.n40 VGND.t12 989330.67152005
RRED897 VGND.n40 VGND.t33 34508.549891963
RRED898 VGND.n40 VGND.t39 126.4766029078
RRED899 VGND.n40 VGND.n3 1675.4726559049
RRED900 VGND.n40 VGND.n48 945585.96064455
RRED901 VGND.n40 VGND.t40 523.7669347609
RRED902 VGND.n40 VGND.n12 452768.62634393
RRED903 VGND.n40 VGND.t46 293591.04169063
RRED904 VGND.n40 VGND.n0 55357.466855315
RRED905 VGND.n40 VGND.t6 235846.20366022
RRED906 VGND.n40 VGND.t16 407738.60090259
RRED907 VGND.n40 VGND.t17 234499614.46583
RRED908 VGND.n40 VGND.t0 427276.67637938
RRED909 VGND.n40 VGND.t1 37898145.299271
RRED910 VGND.t30 VGND.t12 1583.9391208631
RRED911 VGND.t30 VGND.n48 183963.66578278
RRED912 VGND.t30 VGND.n3 8516.3999333696
RRED913 VGND.t30 VGND.n0 636.82554095278
RRED914 VGND.t30 VGND.t46 51230.944903632
RRED915 VGND.t30 VGND.t6 41154.606747776
RRED916 VGND.t30 VGND.t0 74558.773115651
RRED917 VGND.t30 VGND.t1 6613137.0446335
RRED918 VGND.t30 VGND.n12 742.54867950722
RRED919 VGND.t30 VGND.t33 166239.36574374
RRED920 VGND.t30 VGND.t28 9776645.7224544
RRED921 VGND.t12 VGND.t33 1856.6944469919
RRED922 VGND.t12 VGND.t28 54467.282604429
RRED923 VGND.t12 VGND.n12 512.73857299722
RRED924 VGND.t12 VGND.n3 13106.649876869
RRED925 VGND.t12 VGND.n0 1047.4863318254
RRED926 VGND.t10 VGND.t28 1616.06
RRED927 VGND.t10 VGND.t31 3238.0196863009
RRED928 VGND.t10 VGND.n10 619.73025482468
RRED929 VGND.t10 VGND.t11 42092.672340279
RRED930 VGND.t10 VGND.n12 642.15659727005
RRED931 VGND.t28 VGND.t33 1899.8571391168
RRED932 VGND.t28 VGND.n12 332.0652856374
RRED933 VGND.t28 VGND.n3 1607951.8250882
RRED934 VGND.t28 VGND.n0 128507.86240855
RRED935 VGND.n48 VGND.t46 210976.51158274
RRED936 VGND.n48 VGND.n0 3769.9366265564
RRED937 VGND.n48 VGND.t6 169480.67976372
RRED938 VGND.n48 VGND.t16 18.097957454541
RRED939 VGND.n48 VGND.t17 10408.541363686
RRED940 VGND.n48 VGND.n3 324.62733876658
RRED941 VGND.n48 VGND.t40 13413.930428656
RRED942 VGND.n48 VGND.t0 2130.4810350424
RRED943 VGND.n48 VGND.t1 188967.2062317
RRED944 VGND.t0 VGND.t1 8462.1311598051
RRED945 VGND.t0 VGND.n0 182.8374082998
RRED946 VGND.t0 VGND.t46 85506.82980194
RRED947 VGND.t0 VGND.t6 68688.952768045
RRED948 VGND.t31 VGND.n10 352.18845782925
RRED949 VGND.t33 VGND.n12 423.85231186506
RRED950 VGND.t33 VGND.n3 27341.165788102
RRED951 VGND.t33 VGND.n0 2185.1119644047
RRED952 VGND.t6 VGND.n0 272.34900691647
RRED953 VGND.t6 VGND.t46 47197.664442378
RRED954 VGND.t6 VGND.t1 6092501.7824909
RRED955 VGND.t46 VGND.n0 271.89518751285
RRED956 VGND.t46 VGND.t1 7584196.4681375
RRED957 VGND.t1 VGND.n0 108.49075763103
RRED958 VGND.n12 VGND.t29 100.672
RRED959 VGND.n12 VGND.t11 192.08870850123
RRED960 VGND.n12 VGND.n10 3.2991586769026
RRED961 VGND.n12 VGND.n3 122.12598659356
RRED962 VGND.n12 VGND.n0 9.7603356249885
RRED963 VGND.t11 VGND.n10 216.25629289774
RRED964 VGND.n10 VGND.t32 100.672
RRED965 VGND.n10 VGND.n9 19.756228403419
RRED966 VGND.n10 VGND.t2 28.257497852268
RRED967 VGND.n10 VGND.t22 28.257497852268
RRED968 VGND.n10 VGND.t8 85.98073850219
RRED969 VGND.n10 VGND.t14 85.98073850219
RRED970 VGND.n10 VGND 78.485208351393
RRED971 VGND.t17 VGND.n3 84.887454946322
RRED972 VGND.t17 VGND.t16 9327.6220433199
RRED973 VGND.t17 VGND.t40 342870.1272015
RRED974 VGND.n3 VGND.n0 111.94272370329
RRED975 VGND.n3 VGND.t39 151.379286842
RRED976 VGND.n3 VGND.t16 283.23414818562
RRED977 VGND.n3 VGND.t40 150.64267424937
RRED978 VGND.n0 VGND.t7 36.0163
RRED979 VGND.n0 VGND.t47 36.0163
RRED980 VGND.n9 uio_oe[7] 3.52539
RRED981 VGND.n9 uio_oe[6] 3.52539
RRED982 VGND.n9 uio_oe[5] 3.52539
RRED983 VGND.n9 uio_oe[4] 11.66506
RRED984 VGND.n9 uio_oe[3] 11.66506
RRED985 VGND.n9 uio_oe[2] 11.66506
RRED986 VGND.n9 uio_oe[1] 11.66506
RRED987 VGND.n9 VGND.n7 3.8170140790664
RRED988 VGND.n9 VGND.t2 51.311917811468
RRED989 VGND.n9 VGND.t22 51.311917811468
RRED990 VGND.n9 VGND.t8 156.12976812239
RRED991 VGND.n9 VGND.t14 156.12976812239
RRED992 VGND.n9 VGND 142.51886636946
RRED993 VGND.t34 VGND.t8 1.06108
RRED994 VGND.t34 VGND.t18 6.554147364673
RRED995 VGND.t34 VGND.t4 16.853947767187
RRED996 VGND.t34 VGND.t24 11.585284462358
RRED997 VGND.t4 VGND.t2 1.06108
RRED998 VGND.t4 VGND.t24 3.2770736823365
RRED999 VGND.t4 VGND.t18 7.7235229749056
RRED1000 VGND.t4 VGND.t8 16.853947767187
RRED1001 VGND.t4 VGND.t14 23.170568924717
RRED1002 VGND.t2 VGND.t22 3.2924816623189
RRED1003 VGND.t2 VGND.t8 8.8026272430718
RRED1004 VGND.t2 VGND.t14 6.4902562415703
RRED1005 VGND.t2 VGND 37.102819532336
RRED1006 VGND.t8 VGND.t14 2.672899050974
RRED1007 VGND.t8 VGND 13.234054590476
RRED1008 VGND.t8 VGND.t18 13.108294729346
RRED1009 VGND.t8 VGND.t24 11.585284462358
RRED1010 VGND.t8 VGND.t22 6.4902562415703
RRED1011 VGND.t40 VGND.t16 596.16893731314
RRED1012 uo_out[0] uo_out[4] 26.551048338478
RRED1013 uo_out[0] uo_out[3] 26.551048338478
RRED1014 uo_out[0] uo_out[2] 26.551048338478
RRED1015 uo_out[0] uo_out[1] 26.551048338478
RRED1016 uo_out[0] VGND.n5 13.030038869572
RRED1017 VGND.t22 VGND.t24 1.06108
RRED1018 VGND.t22 VGND.t14 4.6957495855147
RRED1019 VGND.t22 VGND 37.102819532336
RRED1020 VGND.t14 VGND.t18 1.06108
RRED1021 VGND.t14 VGND 13.234054590476
RRED1022 VGND.t14 VGND.t24 15.927285159276
RRED1023 uio_oe[4] uio_oe[3] 35.649233140078
RRED1024 uio_oe[4] uio_oe[2] 35.649233140078
RRED1025 uio_oe[4] uio_oe[1] 35.649233140078
RRED1026 uio_oe[4] VGND.n7 11.66506
RRED1027 uio_oe[3] uio_oe[2] 35.649233140078
RRED1028 uio_oe[3] uio_oe[1] 35.649233140078
RRED1029 uio_oe[3] VGND.n7 11.66506
RRED1030 uio_oe[2] uio_oe[1] 35.649233140078
RRED1031 uio_oe[2] VGND.n7 11.66506
RRED1032 uio_oe[1] VGND.n7 11.66506
RRED1033 VGND.n7 uio_oe[0] 3.52539
RRED1034 VGND.n7 uio_out[7] 3.52539
RRED1035 VGND.n7 uio_out[6] 3.52539
RRED1036 VGND.n7 uio_out[5] 3.52539
RRED1037 VGND.n7 uio_out[4] 11.66506
RRED1038 VGND.n7 uio_out[3] 11.66506
RRED1039 VGND.n7 uio_out[2] 11.66506
RRED1040 VGND.n7 uio_out[1] 11.66506
RRED1041 VGND.n7 VGND.n5 3.8170140790664
RRED1042 uio_out[4] uio_out[3] 35.649233140078
RRED1043 uio_out[4] uio_out[2] 35.649233140078
RRED1044 uio_out[4] uio_out[1] 35.649233140078
RRED1045 uio_out[4] VGND.n5 11.66506
RRED1046 uio_out[3] uio_out[2] 35.649233140078
RRED1047 uio_out[3] uio_out[1] 35.649233140078
RRED1048 uio_out[3] VGND.n5 11.66506
RRED1049 uio_out[2] uio_out[1] 35.649233140078
RRED1050 uio_out[2] VGND.n5 11.66506
RRED1051 uio_out[1] VGND.n5 11.66506
RRED1052 VGND.n5 uio_out[0] 3.52539
RRED1053 VGND.n5 uo_out[7] 3.52539
RRED1054 VGND.n5 uo_out[6] 3.52539
RRED1055 VGND.n5 uo_out[5] 3.52539
RRED1056 VGND.n5 uo_out[4] 12.045113809411
RRED1057 VGND.n5 uo_out[3] 12.045113809411
RRED1058 VGND.n5 uo_out[2] 12.045113809411
RRED1059 VGND.n5 uo_out[1] 12.045113809411
RRED1060 uo_out[4] uo_out[3] 24.54408633753
RRED1061 uo_out[4] uo_out[2] 24.54408633753
RRED1062 uo_out[4] uo_out[1] 24.54408633753
RRED1063 uo_out[3] uo_out[2] 24.54408633753
RRED1064 uo_out[3] uo_out[1] 24.54408633753
RRED1065 uo_out[2] uo_out[1] 24.54408633753
RRED1066 VGND.t18 VGND.t24 5.3090950530919
RRED1067 MIRROR.n5 MIRROR.n4 121.276
RRED1068 MIRROR.n5 MIRROR 28.3423
RRED1069 MIRROR.n5 MIRROR.n6 6.19208
RRED1070 MIRROR.n4 MIRROR.n3 67.22
RRED1071 MIRROR.n4 MIRROR.t3 48.2005
RRED1072 MIRROR.n9 MIRROR.n8 121.276
RRED1073 MIRROR.n9 MIRROR 28.3423
RRED1074 MIRROR.n9 MIRROR.n10 6.19208
RRED1075 MIRROR.n8 MIRROR.n7 67.22
RRED1076 MIRROR.n8 MIRROR.t0 48.2005
RRED1077 MIRROR.n13 MIRROR.n12 117.434
RRED1078 MIRROR.n13 MIRROR 31.9563
RRED1079 MIRROR.n13 MIRROR.n11 2.51099
RRED1080 MIRROR.n12 MIRROR.t2 7.14175
RRED1081 MIRROR.n12 MIRROR 431.3595688702
RRED1082 MIRROR.n12 MIRROR.n11 129.18407069754
RRED1083 MIRROR.n3 MIRROR.n6 3.97386
RRED1084 MIRROR.n3 MIRROR 3.22741
RRED1085 MIRROR.n7 MIRROR.n10 3.97386
RRED1086 MIRROR.n7 MIRROR 3.22741
RRED1087 MIRROR MIRROR.n1 5.10833
RRED1088 MIRROR MIRROR.n0 12.808
RRED1089 MIRROR MIRROR.n11 7.3563101999372
RRED1090 MIRROR.n1 MIRROR.n0 19.0053
RRED1091 MIRROR.n1 MIRROR.t1 21.5371
RRED1092 MIRROR.n11 MIRROR.n0 18.4757
RRED1093 MIRROR.n0 MIRROR.n6 18.0121
RRED1094 MIRROR.n0 MIRROR.n10 17.2444
RRED1095 AMP.n3 AMP.t3 482
RRED1096 AMP.n3 AMP.n2 170.624
RRED1097 AMP.n3 AMP.n4 170.624
RRED1098 AMP.n2 AMP 12.8005
RRED1099 AMP.n2 AMP.n5 10.0806
RRED1100 AMP.n4 AMP 12.8005
RRED1101 AMP.n4 AMP.n5 10.0806
RRED1102 AMP.n12 AMP.n11 117.434
RRED1103 AMP.n12 AMP 31.9563
RRED1104 AMP.n12 AMP.n10 2.51099
RRED1105 AMP.n11 AMP.t0 7.14175
RRED1106 AMP.n11 AMP 431.3595688702
RRED1107 AMP.n11 AMP.n10 129.18407069754
RRED1108 AMP.n8 AMP.n7 71.802
RRED1109 AMP.n8 AMP 7.04267
RRED1110 AMP.n8 AMP.n9 4.00594
RRED1111 AMP.n7 AMP.t1 56.9009
RRED1112 AMP.n7 AMP 6.17712
RRED1113 AMP AMP.n0 5.10833
RRED1114 AMP AMP.n10 7.3563101999372
RRED1115 AMP.n0 AMP.n6 19.6303
RRED1116 AMP.n0 AMP.t2 21.5371
RRED1117 AMP.n10 AMP.n9 19.1007
RRED1118 AMP.n9 AMP.n6 2.33483
RRED1119 AMP.n6 AMP.n5 17.1293
RRED1120 TAIL.t1 TAIL.n0 60.703
RRED1121 TAIL.n0 TAIL 5.23741
RRED1122 TAIL.n0 TAIL.n4 19.5414
RRED1123 TAIL TAIL.n1 5.23741
RRED1124 TAIL TAIL.n3 10.2804
RRED1125 TAIL TAIL.n2 5.23741
RRED1126 TAIL.n1 TAIL.n4 20.309
RRED1127 TAIL.n1 TAIL.t2 60.703
RRED1128 TAIL.n4 TAIL.n3 1.18594
RRED1129 TAIL.n3 TAIL.n2 19.3182
RRED1130 TAIL.n2 TAIL.t0 60.703
RRED1131 HOLD.t0 HOLD 555.04426477084
RRED1132 HOLD.t0 HOLD.n9 324.45008123357
RRED1133 HOLD.t2 HOLD 416.89180534393
RRED1134 HOLD.t2 HOLD.n6 328.30901394086
RRED1135 HOLD.n25 HOLD.n24 26.473
RRED1136 HOLD.n25 HOLD.n0 6.75806
RRED1137 HOLD.n25 HOLD 2.34267
RRED1138 HOLD.n24 HOLD.n20 6.21925
RRED1139 HOLD.n24 HOLD.n23 5.67862
RRED1140 HOLD.n17 HOLD 5.4914021922048
RRED1141 HOLD.n17 HOLD.n18 5.71925
RRED1142 HOLD HOLD.n13 5.4914021922048
RRED1143 HOLD HOLD.n21 4.5631253719296
RRED1144 HOLD HOLD.n10 4.5631253719296
RRED1145 HOLD HOLD.n19 11.5981
RRED1146 HOLD HOLD.n15 11.5981
RRED1147 HOLD HOLD.n23 7.08874
RRED1148 HOLD HOLD.n22 7.08874
RRED1149 HOLD HOLD.n18 7.08874
RRED1150 HOLD HOLD.n14 7.08874
RRED1151 HOLD HOLD.n12 7.08874
RRED1152 HOLD HOLD.n11 7.08874
RRED1153 HOLD HOLD.n26 11.654818563781
RRED1154 HOLD HOLD.t1 134.25754718466
RRED1155 HOLD HOLD.n6 11.618927311748
RRED1156 HOLD HOLD.n9 6.0770867516712
RRED1157 HOLD.n13 HOLD.n14 5.71925
RRED1158 HOLD.n0 HOLD.n6 18.4261
RRED1159 HOLD.n0 HOLD.n9 17.6833
RRED1160 HOLD.n0 HOLD.n26 17.2737
RRED1161 HOLD.t1 HOLD.n26 216.39184366571
RRED1162 HOLD.n11 HOLD.n10 17.2817
RRED1163 HOLD.n11 HOLD.n12 5.71925
RRED1164 HOLD.n22 HOLD.n21 17.2817
RRED1165 HOLD.n22 HOLD.n23 5.71925
RRED1166 HOLD.n15 HOLD.n14 12.7411
RRED1167 HOLD.n15 HOLD.n16 4.5005
RRED1168 HOLD.n19 HOLD.n18 12.7411
RRED1169 HOLD.n19 HOLD.n20 4.5005
RRED1170 HOLD.n16 HOLD.n12 11.8974
RRED1171 HOLD.n16 HOLD.n20 6.21925
RRED1172 SAMPLE.t1 SAMPLE 555.04426477084
RRED1173 SAMPLE.t1 SAMPLE.n7 324.45008123357
RRED1174 SAMPLE.t2 SAMPLE 555.04426477084
RRED1175 SAMPLE.t2 SAMPLE.n14 324.45008123357
RRED1176 SAMPLE.t0 SAMPLE 555.04426477084
RRED1177 SAMPLE.t0 SAMPLE.n37 324.45008123357
RRED1178 SAMPLE.n30 SAMPLE.n29 26.3167
RRED1179 SAMPLE.n30 SAMPLE.n1 3.53594
RRED1180 SAMPLE.n30 SAMPLE 1.55933
RRED1181 SAMPLE.n29 SAMPLE.n25 6.21925
RRED1182 SAMPLE.n29 SAMPLE.n28 4.5005
RRED1183 SAMPLE.n26 SAMPLE 5.4257483938482
RRED1184 SAMPLE.n26 SAMPLE.n27 5.71925
RRED1185 SAMPLE SAMPLE.n15 5.4257483938482
RRED1186 SAMPLE SAMPLE.n22 4.5085648173479
RRED1187 SAMPLE SAMPLE.n18 4.5085648173479
RRED1188 SAMPLE SAMPLE.n28 9.15365
RRED1189 SAMPLE SAMPLE.n17 9.15365
RRED1190 SAMPLE SAMPLE.n27 6.98802
RRED1191 SAMPLE SAMPLE.n24 6.98802
RRED1192 SAMPLE SAMPLE.n23 6.98802
RRED1193 SAMPLE SAMPLE.n20 6.98802
RRED1194 SAMPLE SAMPLE.n19 6.98802
RRED1195 SAMPLE SAMPLE.n16 6.98802
RRED1196 SAMPLE SAMPLE.n11 11.654818563781
RRED1197 SAMPLE SAMPLE.n14 6.0770867516712
RRED1198 SAMPLE SAMPLE.n38 11.654818563781
RRED1199 SAMPLE SAMPLE.n34 11.654818563781
RRED1200 SAMPLE SAMPLE.t5 134.25754718466
RRED1201 SAMPLE SAMPLE.n37 6.0770867516712
RRED1202 SAMPLE SAMPLE.t3 134.25754718466
RRED1203 SAMPLE SAMPLE.n7 6.0770867516712
RRED1204 SAMPLE SAMPLE.t4 134.25754718466
RRED1205 SAMPLE.n15 SAMPLE.n16 5.71925
RRED1206 SAMPLE.n0 SAMPLE.n7 17.7215
RRED1207 SAMPLE.n0 SAMPLE.n14 17.0583
RRED1208 SAMPLE.n0 SAMPLE.n11 16.6487
RRED1209 SAMPLE.n0 SAMPLE.n2 1.32694
RRED1210 SAMPLE.t3 SAMPLE.n38 216.39184366571
RRED1211 SAMPLE.t4 SAMPLE.n11 216.39184366571
RRED1212 SAMPLE.t5 SAMPLE.n34 216.39184366571
RRED1213 SAMPLE.n19 SAMPLE.n18 17.2817
RRED1214 SAMPLE.n19 SAMPLE.n20 5.71925
RRED1215 SAMPLE.n23 SAMPLE.n22 17.2817
RRED1216 SAMPLE.n23 SAMPLE.n24 5.71925
RRED1217 SAMPLE.n2 SAMPLE.n37 17.0583
RRED1218 SAMPLE.n2 SAMPLE.n38 16.6487
RRED1219 SAMPLE.n2 SAMPLE.n1 1.53583
RRED1220 SAMPLE.n1 SAMPLE.n34 16.6487
RRED1221 SAMPLE.n17 SAMPLE.n16 15.0849
RRED1222 SAMPLE.n17 SAMPLE.n21 10.7193
RRED1223 SAMPLE.n28 SAMPLE.n27 15.0849
RRED1224 SAMPLE.n21 SAMPLE.n20 8.02238
RRED1225 SAMPLE.n21 SAMPLE.n25 6.21925
RRED1226 SAMPLE.n25 SAMPLE.n24 8.02238
RRED1227 S_BAR.n7 S_BAR.t0 407.813
RRED1228 S_BAR.n7 S_BAR 4.62024
RRED1229 S_BAR.n7 S_BAR.n6 2.70094
RRED1230 S_BAR.t0 S_BAR.n1 401.517
RRED1231 S_BAR.n1 S_BAR 21.688
RRED1232 S_BAR.n1 S_BAR.n6 12.6768
RRED1233 S_BAR S_BAR.t2 333.784
RRED1234 S_BAR S_BAR.n0 3.5962421248326
RRED1235 S_BAR S_BAR.n4 13.5534
RRED1236 S_BAR S_BAR.n2 6.33895
RRED1237 S_BAR.n4 S_BAR.n3 197.048
RRED1238 S_BAR.n4 S_BAR.n5 9.32224
RRED1239 S_BAR.n3 S_BAR.n2 92.1489
RRED1240 S_BAR.n3 S_BAR.t1 17.4005
RRED1241 S_BAR.n2 S_BAR.n5 16.0734
RRED1242 S_BAR.n0 S_BAR.n6 15.719
RRED1243 S_BAR.n0 S_BAR.n5 15.7112
RRED1244 L_BAR.n7 L_BAR.t0 407.813
RRED1245 L_BAR.n7 L_BAR 4.62024
RRED1246 L_BAR.n7 L_BAR.n6 2.70094
RRED1247 L_BAR.t0 L_BAR.n1 401.517
RRED1248 L_BAR.n1 L_BAR 21.688
RRED1249 L_BAR.n1 L_BAR.n6 12.6768
RRED1250 L_BAR L_BAR.t2 333.784
RRED1251 L_BAR L_BAR.n0 2.3308464406706
RRED1252 L_BAR L_BAR.n4 13.5534
RRED1253 L_BAR L_BAR.n2 6.33895
RRED1254 L_BAR.n4 L_BAR.n3 197.048
RRED1255 L_BAR.n4 L_BAR.n5 9.32224
RRED1256 L_BAR.n3 L_BAR.n2 92.1489
RRED1257 L_BAR.n3 L_BAR.t1 17.4005
RRED1258 L_BAR.n2 L_BAR.n5 16.0734
RRED1259 L_BAR.n0 L_BAR.n6 15.4065
RRED1260 L_BAR.n0 L_BAR.n5 15.3987
RRED1261 H_BAR.n6 H_BAR.t0 407.813
RRED1262 H_BAR.n6 H_BAR 4.62024
RRED1263 H_BAR.n6 H_BAR.n5 2.70094
RRED1264 H_BAR.t0 H_BAR.n0 401.517
RRED1265 H_BAR.n0 H_BAR 21.688
RRED1266 H_BAR.n0 H_BAR.n5 12.6768
RRED1267 H_BAR H_BAR.t2 333.784
RRED1268 H_BAR H_BAR.n4 15.8538
RRED1269 H_BAR H_BAR.n5 15.094
RRED1270 H_BAR H_BAR.n3 13.5534
RRED1271 H_BAR H_BAR.n1 6.33895
RRED1272 H_BAR.n3 H_BAR.n2 197.048
RRED1273 H_BAR.n3 H_BAR.n4 9.32224
RRED1274 H_BAR.n2 H_BAR.n1 92.1489
RRED1275 H_BAR.n2 H_BAR.t1 17.4005
RRED1276 H_BAR.n1 H_BAR.n4 16.0734
RRED1277 BIAS.n4 BIAS.t3 289.2
RRED1278 BIAS.n4 BIAS.n5 117.15
RRED1279 BIAS.n4 BIAS.n3 65.9614
RRED1280 BIAS.n2 BIAS.n1 117.434
RRED1281 BIAS.n2 BIAS.t1 7.14175
RRED1282 BIAS.n2 BIAS 431.3595688702
RRED1283 BIAS.n2 BIAS.n17 129.18407069754
RRED1284 BIAS.n1 BIAS 31.9563
RRED1285 BIAS.n1 BIAS.n17 2.51099
RRED1286 BIAS.n5 BIAS 28.3694
RRED1287 BIAS.n5 BIAS.n6 6.16394
RRED1288 BIAS.n9 BIAS.n8 117.15
RRED1289 BIAS.n9 BIAS 28.3694
RRED1290 BIAS.n9 BIAS.n10 6.16394
RRED1291 BIAS.n8 BIAS.n7 65.9614
RRED1292 BIAS.n8 BIAS.t4 48.2005
RRED1293 BIAS.n13 BIAS.n12 117.15
RRED1294 BIAS.n13 BIAS 28.3694
RRED1295 BIAS.n13 BIAS.n14 6.16394
RRED1296 BIAS.n12 BIAS.n11 65.9614
RRED1297 BIAS.n12 BIAS.t0 48.2005
RRED1298 BIAS.n16 BIAS.n15 76.3926
RRED1299 BIAS.n16 BIAS 5.476
RRED1300 BIAS.n16 BIAS.n0 4.96683
RRED1301 BIAS.n15 BIAS.t2 56.9009
RRED1302 BIAS.n15 BIAS 6.17712
RRED1303 BIAS.n3 BIAS.n6 3.92068
RRED1304 BIAS.n3 BIAS 3.27839
RRED1305 BIAS.n7 BIAS.n10 3.92068
RRED1306 BIAS.n7 BIAS 3.27839
RRED1307 BIAS.n11 BIAS.n14 3.92068
RRED1308 BIAS.n11 BIAS 3.27839
RRED1309 BIAS BIAS.n17 7.3563101999372
RRED1310 BIAS.n17 BIAS.n0 17.6275
RRED1311 BIAS.n0 BIAS.n6 17.3891
RRED1312 BIAS.n0 BIAS.n10 16.6131
RRED1313 BIAS.n0 BIAS.n14 16.6131
.ends
